* NGSPICE file created from soc_top.ext - technology: sky130A

* Black-box entry subcircuit for sky130_fd_sc_hd__fill_2 abstract view
.subckt sky130_fd_sc_hd__fill_2 VGND VNB VPB VPWR
.ends

* Black-box entry subcircuit for sky130_fd_sc_hd__decap_3 abstract view
.subckt sky130_fd_sc_hd__decap_3 VGND VNB VPB VPWR
.ends

* Black-box entry subcircuit for sky130_fd_sc_hd__fill_1 abstract view
.subckt sky130_fd_sc_hd__fill_1 VGND VNB VPB VPWR
.ends

* Black-box entry subcircuit for sky130_fd_sc_hd__conb_1 abstract view
.subckt sky130_fd_sc_hd__conb_1 VGND VNB VPB VPWR HI LO
.ends

* Black-box entry subcircuit for sky130_fd_sc_hd__dlygate4sd3_1 abstract view
.subckt sky130_fd_sc_hd__dlygate4sd3_1 A VGND VNB VPB VPWR X
.ends

* Black-box entry subcircuit for sky130_fd_sc_hd__clkdlybuf4s25_1 abstract view
.subckt sky130_fd_sc_hd__clkdlybuf4s25_1 A VGND VNB VPB VPWR X
.ends

* Black-box entry subcircuit for sky130_fd_sc_hd__tapvpwrvgnd_1 abstract view
.subckt sky130_fd_sc_hd__tapvpwrvgnd_1 VGND VPWR
.ends

* Black-box entry subcircuit for sky130_fd_sc_hd__dfrtp_2 abstract view
.subckt sky130_fd_sc_hd__dfrtp_2 CLK D RESET_B VGND VNB VPB VPWR Q
.ends

* Black-box entry subcircuit for sky130_fd_sc_hd__xnor2_2 abstract view
.subckt sky130_fd_sc_hd__xnor2_2 A B VGND VNB VPB VPWR Y
.ends

* Black-box entry subcircuit for sky130_fd_sc_hd__clkbuf_8 abstract view
.subckt sky130_fd_sc_hd__clkbuf_8 A VGND VNB VPB VPWR X
.ends

* Black-box entry subcircuit for sky130_fd_sc_hd__and2b_2 abstract view
.subckt sky130_fd_sc_hd__and2b_2 A_N B VGND VNB VPB VPWR X
.ends

* Black-box entry subcircuit for sky130_fd_sc_hd__nand2_2 abstract view
.subckt sky130_fd_sc_hd__nand2_2 A B VGND VNB VPB VPWR Y
.ends

* Black-box entry subcircuit for sky130_fd_sc_hd__a31oi_2 abstract view
.subckt sky130_fd_sc_hd__a31oi_2 A1 A2 A3 B1 VGND VNB VPB VPWR Y
.ends

* Black-box entry subcircuit for sky130_fd_sc_hd__xor2_2 abstract view
.subckt sky130_fd_sc_hd__xor2_2 A B VGND VNB VPB VPWR X
.ends

* Black-box entry subcircuit for sky130_fd_sc_hd__nor2_2 abstract view
.subckt sky130_fd_sc_hd__nor2_2 A B VGND VNB VPB VPWR Y
.ends

* Black-box entry subcircuit for sky130_fd_sc_hd__and2_2 abstract view
.subckt sky130_fd_sc_hd__and2_2 A B VGND VNB VPB VPWR X
.ends

* Black-box entry subcircuit for sky130_fd_sc_hd__a31o_2 abstract view
.subckt sky130_fd_sc_hd__a31o_2 A1 A2 A3 B1 VGND VNB VPB VPWR X
.ends

* Black-box entry subcircuit for sky130_fd_sc_hd__nor3b_2 abstract view
.subckt sky130_fd_sc_hd__nor3b_2 A B C_N VGND VNB VPB VPWR Y
.ends

* Black-box entry subcircuit for sky130_fd_sc_hd__nand2b_2 abstract view
.subckt sky130_fd_sc_hd__nand2b_2 A_N B VGND VNB VPB VPWR Y
.ends

.subckt soc_top VGND VPWR clk instruct_en0 instruct_en1 result0[0] result0[10] result0[11]
+ result0[12] result0[13] result0[14] result0[15] result0[16] result0[17] result0[18]
+ result0[19] result0[1] result0[20] result0[21] result0[22] result0[23] result0[24]
+ result0[25] result0[26] result0[27] result0[28] result0[29] result0[2] result0[30]
+ result0[31] result0[3] result0[4] result0[5] result0[6] result0[7] result0[8] result0[9]
+ result1[0] result1[10] result1[11] result1[12] result1[13] result1[14] result1[15]
+ result1[16] result1[17] result1[18] result1[19] result1[1] result1[20] result1[21]
+ result1[22] result1[23] result1[24] result1[25] result1[26] result1[27] result1[28]
+ result1[29] result1[2] result1[30] result1[31] result1[3] result1[4] result1[5]
+ result1[6] result1[7] result1[8] result1[9] rst
XFILLER_12_54 VGND VGND VPWR VPWR sky130_fd_sc_hd__fill_2
XFILLER_12_65 VGND VGND VPWR VPWR sky130_fd_sc_hd__fill_2
XFILLER_3_12 VGND VGND VPWR VPWR sky130_fd_sc_hd__decap_3
XFILLER_0_46 VGND VGND VPWR VPWR sky130_fd_sc_hd__decap_3
XFILLER_0_57 VGND VGND VPWR VPWR sky130_fd_sc_hd__fill_1
XFILLER_9_11 VGND VGND VPWR VPWR sky130_fd_sc_hd__decap_3
Xsoc_top_57 VGND VGND VPWR VPWR soc_top_57/HI result1[7] sky130_fd_sc_hd__conb_1
Xsoc_top_46 VGND VGND VPWR VPWR soc_top_46/HI result1[18] sky130_fd_sc_hd__conb_1
Xsoc_top_35 VGND VGND VPWR VPWR soc_top_35/HI result1[29] sky130_fd_sc_hd__conb_1
Xsoc_top_24 VGND VGND VPWR VPWR soc_top_24/HI result0[14] sky130_fd_sc_hd__conb_1
Xsoc_top_13 VGND VGND VPWR VPWR soc_top_13/HI result0[25] sky130_fd_sc_hd__conb_1
XPHY_EDGE_ROW_12_Left_25 VGND VGND VPWR VPWR sky130_fd_sc_hd__decap_3
Xhold74 _30_/Q VGND VGND VPWR VPWR _13_/B sky130_fd_sc_hd__dlygate4sd3_1
XFILLER_3_24 VGND VGND VPWR VPWR sky130_fd_sc_hd__decap_3
XFILLER_3_57 VGND VGND VPWR VPWR sky130_fd_sc_hd__decap_3
Xoutput7 _12_/Y VGND VGND VPWR VPWR result1[2] sky130_fd_sc_hd__clkdlybuf4s25_1
XPHY_EDGE_ROW_0_Left_13 VGND VGND VPWR VPWR sky130_fd_sc_hd__decap_3
XPHY_EDGE_ROW_12_Right_12 VGND VGND VPWR VPWR sky130_fd_sc_hd__decap_3
Xsoc_top_58 VGND VGND VPWR VPWR soc_top_58/HI result1[6] sky130_fd_sc_hd__conb_1
Xsoc_top_47 VGND VGND VPWR VPWR soc_top_47/HI result1[17] sky130_fd_sc_hd__conb_1
Xsoc_top_36 VGND VGND VPWR VPWR soc_top_36/HI result1[28] sky130_fd_sc_hd__conb_1
Xsoc_top_25 VGND VGND VPWR VPWR soc_top_25/HI result0[13] sky130_fd_sc_hd__conb_1
Xsoc_top_14 VGND VGND VPWR VPWR soc_top_14/HI result0[24] sky130_fd_sc_hd__conb_1
XFILLER_6_57 VGND VGND VPWR VPWR sky130_fd_sc_hd__decap_3
XPHY_EDGE_ROW_6_Right_6 VGND VGND VPWR VPWR sky130_fd_sc_hd__decap_3
Xhold75 _20_/Y VGND VGND VPWR VPWR _30_/D sky130_fd_sc_hd__dlygate4sd3_1
XFILLER_3_36 VGND VGND VPWR VPWR sky130_fd_sc_hd__fill_2
XFILLER_3_3 VGND VGND VPWR VPWR sky130_fd_sc_hd__decap_3
XFILLER_9_46 VGND VGND VPWR VPWR sky130_fd_sc_hd__fill_2
XFILLER_9_57 VGND VGND VPWR VPWR sky130_fd_sc_hd__decap_3
XTAP_TAPCELL_ROW_8_35 VGND VPWR sky130_fd_sc_hd__tapvpwrvgnd_1
Xsoc_top_59 VGND VGND VPWR VPWR soc_top_59/HI result1[5] sky130_fd_sc_hd__conb_1
Xsoc_top_48 VGND VGND VPWR VPWR soc_top_48/HI result1[16] sky130_fd_sc_hd__conb_1
Xsoc_top_37 VGND VGND VPWR VPWR soc_top_37/HI result1[27] sky130_fd_sc_hd__conb_1
Xsoc_top_26 VGND VGND VPWR VPWR soc_top_26/HI result0[12] sky130_fd_sc_hd__conb_1
Xsoc_top_15 VGND VGND VPWR VPWR soc_top_15/HI result0[23] sky130_fd_sc_hd__conb_1
XFILLER_6_47 VGND VGND VPWR VPWR sky130_fd_sc_hd__decap_3
XFILLER_3_15 VGND VGND VPWR VPWR sky130_fd_sc_hd__decap_3
Xsoc_top_49 VGND VGND VPWR VPWR soc_top_49/HI result1[15] sky130_fd_sc_hd__conb_1
Xsoc_top_38 VGND VGND VPWR VPWR soc_top_38/HI result1[26] sky130_fd_sc_hd__conb_1
Xsoc_top_27 VGND VGND VPWR VPWR soc_top_27/HI result0[11] sky130_fd_sc_hd__conb_1
Xsoc_top_16 VGND VGND VPWR VPWR soc_top_16/HI result0[22] sky130_fd_sc_hd__conb_1
XFILLER_0_16 VGND VGND VPWR VPWR sky130_fd_sc_hd__decap_3
X_29_ _29_/CLK _29_/D input3/X VGND VGND VPWR VPWR _29_/Q sky130_fd_sc_hd__dfrtp_2
XFILLER_3_27 VGND VGND VPWR VPWR sky130_fd_sc_hd__decap_3
XPHY_EDGE_ROW_4_Left_17 VGND VGND VPWR VPWR sky130_fd_sc_hd__decap_3
Xsoc_top_39 VGND VGND VPWR VPWR soc_top_39/HI result1[25] sky130_fd_sc_hd__conb_1
Xsoc_top_28 VGND VGND VPWR VPWR soc_top_28/HI result0[10] sky130_fd_sc_hd__conb_1
Xsoc_top_17 VGND VGND VPWR VPWR soc_top_17/HI result0[21] sky130_fd_sc_hd__conb_1
XPHY_EDGE_ROW_7_Left_20 VGND VGND VPWR VPWR sky130_fd_sc_hd__decap_3
Xhold67 _29_/Q VGND VGND VPWR VPWR _13_/A sky130_fd_sc_hd__dlygate4sd3_1
X_28_ _29_/CLK _28_/D input3/X VGND VGND VPWR VPWR _28_/Q sky130_fd_sc_hd__dfrtp_2
Xsoc_top_29 VGND VGND VPWR VPWR soc_top_29/HI result0[9] sky130_fd_sc_hd__conb_1
Xsoc_top_18 VGND VGND VPWR VPWR soc_top_18/HI result0[20] sky130_fd_sc_hd__conb_1
XFILLER_0_29 VGND VGND VPWR VPWR sky130_fd_sc_hd__fill_2
XFILLER_3_6 VGND VGND VPWR VPWR sky130_fd_sc_hd__decap_3
XFILLER_1_50 VGND VGND VPWR VPWR sky130_fd_sc_hd__decap_3
Xhold68 _18_/Y VGND VGND VPWR VPWR _29_/D sky130_fd_sc_hd__dlygate4sd3_1
X_27_ _31_/CLK _27_/D input3/X VGND VGND VPWR VPWR _27_/Q sky130_fd_sc_hd__dfrtp_2
XFILLER_3_18 VGND VGND VPWR VPWR sky130_fd_sc_hd__decap_3
XFILLER_7_60 VGND VGND VPWR VPWR sky130_fd_sc_hd__decap_3
XTAP_TAPCELL_ROW_2_29 VGND VPWR sky130_fd_sc_hd__tapvpwrvgnd_1
Xsoc_top_19 VGND VGND VPWR VPWR soc_top_19/HI result0[19] sky130_fd_sc_hd__conb_1
Xhold69 _26_/Q VGND VGND VPWR VPWR _22_/B1 sky130_fd_sc_hd__dlygate4sd3_1
X_26_ _29_/CLK _26_/D input3/X VGND VGND VPWR VPWR _26_/Q sky130_fd_sc_hd__dfrtp_2
XFILLER_6_29 VGND VGND VPWR VPWR sky130_fd_sc_hd__decap_3
XPHY_EDGE_ROW_1_Right_1 VGND VGND VPWR VPWR sky130_fd_sc_hd__decap_3
XTAP_TAPCELL_ROW_12_39 VGND VPWR sky130_fd_sc_hd__tapvpwrvgnd_1
XFILLER_4_73 VGND VGND VPWR VPWR sky130_fd_sc_hd__fill_2
XFILLER_1_41 VGND VGND VPWR VPWR sky130_fd_sc_hd__decap_3
X_25_ _25_/A _25_/B VGND VGND VPWR VPWR _25_/Y sky130_fd_sc_hd__xnor2_2
XTAP_TAPCELL_ROW_3_30 VGND VPWR sky130_fd_sc_hd__tapvpwrvgnd_1
Xclkbuf_0_clk clk VGND VGND VPWR VPWR clkbuf_0_clk/X sky130_fd_sc_hd__clkbuf_8
XFILLER_12_29 VGND VGND VPWR VPWR sky130_fd_sc_hd__fill_2
XFILLER_3_9 VGND VGND VPWR VPWR sky130_fd_sc_hd__decap_3
XFILLER_1_20 VGND VGND VPWR VPWR sky130_fd_sc_hd__decap_3
XFILLER_1_53 VGND VGND VPWR VPWR sky130_fd_sc_hd__decap_3
X_24_ _16_/Y _25_/B VGND VGND VPWR VPWR _27_/D sky130_fd_sc_hd__and2b_2
XPHY_EDGE_ROW_11_Left_24 VGND VGND VPWR VPWR sky130_fd_sc_hd__decap_3
XFILLER_7_63 VGND VGND VPWR VPWR sky130_fd_sc_hd__decap_3
XFILLER_1_32 VGND VGND VPWR VPWR sky130_fd_sc_hd__decap_3
X_23_ _26_/Q _27_/Q VGND VGND VPWR VPWR _25_/B sky130_fd_sc_hd__nand2_2
XPHY_EDGE_ROW_5_Right_5 VGND VGND VPWR VPWR sky130_fd_sc_hd__decap_3
XFILLER_4_32 VGND VGND VPWR VPWR sky130_fd_sc_hd__decap_3
XFILLER_1_11 VGND VGND VPWR VPWR sky130_fd_sc_hd__decap_3
XFILLER_1_44 VGND VGND VPWR VPWR sky130_fd_sc_hd__decap_3
X_22_ _22_/A1 _28_/Q _16_/Y _22_/B1 VGND VGND VPWR VPWR _22_/Y sky130_fd_sc_hd__a31oi_2
XFILLER_7_10 VGND VGND VPWR VPWR sky130_fd_sc_hd__decap_3
XPHY_EDGE_ROW_11_Right_11 VGND VGND VPWR VPWR sky130_fd_sc_hd__decap_3
XFILLER_4_22 VGND VGND VPWR VPWR sky130_fd_sc_hd__decap_3
XFILLER_10_54 VGND VGND VPWR VPWR sky130_fd_sc_hd__decap_3
XFILLER_1_23 VGND VGND VPWR VPWR sky130_fd_sc_hd__decap_3
X_21_ _21_/A _21_/B VGND VGND VPWR VPWR _31_/D sky130_fd_sc_hd__xor2_2
XFILLER_7_66 VGND VGND VPWR VPWR sky130_fd_sc_hd__decap_3
XTAP_TAPCELL_ROW_6_33 VGND VPWR sky130_fd_sc_hd__tapvpwrvgnd_1
XFILLER_8_3 VGND VGND VPWR VPWR sky130_fd_sc_hd__fill_2
XPHY_EDGE_ROW_3_Left_16 VGND VGND VPWR VPWR sky130_fd_sc_hd__decap_3
XFILLER_1_35 VGND VGND VPWR VPWR sky130_fd_sc_hd__decap_3
Xinput1 instruct_en0 VGND VGND VPWR VPWR _22_/A1 sky130_fd_sc_hd__clkdlybuf4s25_1
X_20_ _20_/A _21_/B VGND VGND VPWR VPWR _20_/Y sky130_fd_sc_hd__nor2_2
XPHY_EDGE_ROW_9_Right_9 VGND VGND VPWR VPWR sky130_fd_sc_hd__decap_3
XFILLER_4_13 VGND VGND VPWR VPWR sky130_fd_sc_hd__decap_3
XFILLER_4_35 VGND VGND VPWR VPWR sky130_fd_sc_hd__decap_3
XFILLER_1_14 VGND VGND VPWR VPWR sky130_fd_sc_hd__decap_3
XFILLER_1_47 VGND VGND VPWR VPWR sky130_fd_sc_hd__decap_3
Xinput2 instruct_en1 VGND VGND VPWR VPWR _11_/B sky130_fd_sc_hd__clkdlybuf4s25_1
XFILLER_7_13 VGND VGND VPWR VPWR sky130_fd_sc_hd__fill_1
XFILLER_7_57 VGND VGND VPWR VPWR sky130_fd_sc_hd__decap_3
XFILLER_4_25 VGND VGND VPWR VPWR sky130_fd_sc_hd__decap_3
XTAP_TAPCELL_ROW_0_26 VGND VPWR sky130_fd_sc_hd__tapvpwrvgnd_1
XFILLER_10_57 VGND VGND VPWR VPWR sky130_fd_sc_hd__decap_3
XFILLER_1_26 VGND VGND VPWR VPWR sky130_fd_sc_hd__decap_3
Xinput3 rst VGND VGND VPWR VPWR input3/X sky130_fd_sc_hd__clkdlybuf4s25_1
XPHY_EDGE_ROW_0_Right_0 VGND VGND VPWR VPWR sky130_fd_sc_hd__decap_3
XTAP_TAPCELL_ROW_0_27 VGND VPWR sky130_fd_sc_hd__tapvpwrvgnd_1
XFILLER_1_38 VGND VGND VPWR VPWR sky130_fd_sc_hd__decap_3
XFILLER_6_3 VGND VGND VPWR VPWR sky130_fd_sc_hd__decap_3
XTAP_TAPCELL_ROW_9_36 VGND VPWR sky130_fd_sc_hd__tapvpwrvgnd_1
Xsoc_top VGND VGND VPWR VPWR soc_top/HI result0[31] sky130_fd_sc_hd__conb_1
XFILLER_4_16 VGND VGND VPWR VPWR sky130_fd_sc_hd__decap_3
XFILLER_4_38 VGND VGND VPWR VPWR sky130_fd_sc_hd__decap_3
XFILLER_1_17 VGND VGND VPWR VPWR sky130_fd_sc_hd__decap_3
XTAP_TAPCELL_ROW_10_37 VGND VPWR sky130_fd_sc_hd__tapvpwrvgnd_1
XPHY_EDGE_ROW_10_Left_23 VGND VGND VPWR VPWR sky130_fd_sc_hd__decap_3
XFILLER_1_29 VGND VGND VPWR VPWR sky130_fd_sc_hd__decap_3
XFILLER_5_60 VGND VGND VPWR VPWR sky130_fd_sc_hd__decap_3
XFILLER_2_50 VGND VGND VPWR VPWR sky130_fd_sc_hd__decap_3
XFILLER_11_70 VGND VGND VPWR VPWR sky130_fd_sc_hd__fill_2
XPHY_EDGE_ROW_4_Right_4 VGND VGND VPWR VPWR sky130_fd_sc_hd__decap_3
XFILLER_4_29 VGND VGND VPWR VPWR sky130_fd_sc_hd__decap_3
XFILLER_4_3 VGND VGND VPWR VPWR sky130_fd_sc_hd__decap_3
XFILLER_6_6 VGND VGND VPWR VPWR sky130_fd_sc_hd__fill_1
XFILLER_2_62 VGND VGND VPWR VPWR sky130_fd_sc_hd__fill_1
XFILLER_4_19 VGND VGND VPWR VPWR sky130_fd_sc_hd__decap_3
XFILLER_5_40 VGND VGND VPWR VPWR sky130_fd_sc_hd__decap_3
XFILLER_2_41 VGND VGND VPWR VPWR sky130_fd_sc_hd__decap_3
Xclkbuf_1_0__f_clk clkbuf_0_clk/X VGND VGND VPWR VPWR _29_/CLK sky130_fd_sc_hd__clkbuf_8
XFILLER_12_3 VGND VGND VPWR VPWR sky130_fd_sc_hd__decap_3
XFILLER_8_62 VGND VGND VPWR VPWR sky130_fd_sc_hd__decap_3
XFILLER_10_19 VGND VGND VPWR VPWR sky130_fd_sc_hd__fill_1
XFILLER_5_63 VGND VGND VPWR VPWR sky130_fd_sc_hd__decap_3
XPHY_EDGE_ROW_2_Left_15 VGND VGND VPWR VPWR sky130_fd_sc_hd__decap_3
XFILLER_2_53 VGND VGND VPWR VPWR sky130_fd_sc_hd__decap_3
XPHY_EDGE_ROW_10_Right_10 VGND VGND VPWR VPWR sky130_fd_sc_hd__decap_3
XTAP_TAPCELL_ROW_4_31 VGND VPWR sky130_fd_sc_hd__tapvpwrvgnd_1
XPHY_EDGE_ROW_8_Right_8 VGND VGND VPWR VPWR sky130_fd_sc_hd__decap_3
XFILLER_2_21 VGND VGND VPWR VPWR sky130_fd_sc_hd__decap_3
XFILLER_2_32 VGND VGND VPWR VPWR sky130_fd_sc_hd__decap_3
XFILLER_4_6 VGND VGND VPWR VPWR sky130_fd_sc_hd__fill_2
XFILLER_11_52 VGND VGND VPWR VPWR sky130_fd_sc_hd__fill_1
XFILLER_2_3 VGND VGND VPWR VPWR sky130_fd_sc_hd__decap_3
Xsoc_top_8 VGND VGND VPWR VPWR soc_top_8/HI result0[30] sky130_fd_sc_hd__conb_1
XFILLER_5_43 VGND VGND VPWR VPWR sky130_fd_sc_hd__fill_2
XFILLER_2_44 VGND VGND VPWR VPWR sky130_fd_sc_hd__decap_3
Xsoc_top_9 VGND VGND VPWR VPWR soc_top_9/HI result0[29] sky130_fd_sc_hd__conb_1
XFILLER_8_32 VGND VGND VPWR VPWR sky130_fd_sc_hd__decap_3
XFILLER_8_65 VGND VGND VPWR VPWR sky130_fd_sc_hd__fill_1
X_19_ _29_/Q _30_/Q VGND VGND VPWR VPWR _21_/B sky130_fd_sc_hd__and2_2
XFILLER_5_66 VGND VGND VPWR VPWR sky130_fd_sc_hd__decap_3
XFILLER_2_12 VGND VGND VPWR VPWR sky130_fd_sc_hd__decap_3
XFILLER_2_56 VGND VGND VPWR VPWR sky130_fd_sc_hd__decap_3
XPHY_EDGE_ROW_6_Left_19 VGND VGND VPWR VPWR sky130_fd_sc_hd__decap_3
XFILLER_8_22 VGND VGND VPWR VPWR sky130_fd_sc_hd__decap_3
XPHY_EDGE_ROW_9_Left_22 VGND VGND VPWR VPWR sky130_fd_sc_hd__decap_3
X_18_ _11_/B _31_/Q _20_/A _13_/A VGND VGND VPWR VPWR _18_/Y sky130_fd_sc_hd__a31oi_2
XFILLER_5_34 VGND VGND VPWR VPWR sky130_fd_sc_hd__decap_3
XFILLER_11_11 VGND VGND VPWR VPWR sky130_fd_sc_hd__fill_2
XFILLER_2_24 VGND VGND VPWR VPWR sky130_fd_sc_hd__decap_3
XFILLER_2_35 VGND VGND VPWR VPWR sky130_fd_sc_hd__decap_3
XFILLER_2_6 VGND VGND VPWR VPWR sky130_fd_sc_hd__decap_3
XTAP_TAPCELL_ROW_7_34 VGND VPWR sky130_fd_sc_hd__tapvpwrvgnd_1
X_17_ _22_/A1 _28_/Q _16_/Y _15_/Y VGND VGND VPWR VPWR _17_/X sky130_fd_sc_hd__a31o_2
XFILLER_5_57 VGND VGND VPWR VPWR sky130_fd_sc_hd__decap_3
XFILLER_2_47 VGND VGND VPWR VPWR sky130_fd_sc_hd__decap_3
XFILLER_8_35 VGND VGND VPWR VPWR sky130_fd_sc_hd__decap_3
X_16_ _26_/Q _27_/Q VGND VGND VPWR VPWR _16_/Y sky130_fd_sc_hd__nor2_2
XPHY_EDGE_ROW_3_Right_3 VGND VGND VPWR VPWR sky130_fd_sc_hd__decap_3
Xclkbuf_1_1__f_clk clkbuf_0_clk/X VGND VGND VPWR VPWR _31_/CLK sky130_fd_sc_hd__clkbuf_8
XFILLER_11_57 VGND VGND VPWR VPWR sky130_fd_sc_hd__fill_1
XFILLER_2_15 VGND VGND VPWR VPWR sky130_fd_sc_hd__decap_3
XFILLER_2_59 VGND VGND VPWR VPWR sky130_fd_sc_hd__decap_3
XFILLER_8_25 VGND VGND VPWR VPWR sky130_fd_sc_hd__decap_3
X_15_ _26_/Q _28_/Q _22_/A1 VGND VGND VPWR VPWR _15_/Y sky130_fd_sc_hd__nor3b_2
XFILLER_0_70 VGND VGND VPWR VPWR sky130_fd_sc_hd__fill_2
XFILLER_5_37 VGND VGND VPWR VPWR sky130_fd_sc_hd__decap_3
XFILLER_2_27 VGND VGND VPWR VPWR sky130_fd_sc_hd__fill_1
XFILLER_2_38 VGND VGND VPWR VPWR sky130_fd_sc_hd__decap_3
XFILLER_2_9 VGND VGND VPWR VPWR sky130_fd_sc_hd__decap_3
X_31_ _31_/CLK _31_/D input3/X VGND VGND VPWR VPWR _31_/Q sky130_fd_sc_hd__dfrtp_2
XFILLER_0_6 VGND VGND VPWR VPWR sky130_fd_sc_hd__fill_1
X_14_ _11_/B _31_/Q _20_/A _12_/Y VGND VGND VPWR VPWR _14_/X sky130_fd_sc_hd__a31o_2
Xsoc_top_60 VGND VGND VPWR VPWR soc_top_60/HI result0[5] sky130_fd_sc_hd__conb_1
XTAP_TAPCELL_ROW_1_28 VGND VPWR sky130_fd_sc_hd__tapvpwrvgnd_1
XFILLER_3_60 VGND VGND VPWR VPWR sky130_fd_sc_hd__decap_3
XPHY_EDGE_ROW_1_Left_14 VGND VGND VPWR VPWR sky130_fd_sc_hd__decap_3
X_30_ _31_/CLK _30_/D input3/X VGND VGND VPWR VPWR _30_/Q sky130_fd_sc_hd__dfrtp_2
X_13_ _13_/A _13_/B VGND VGND VPWR VPWR _20_/A sky130_fd_sc_hd__nor2_2
Xsoc_top_61 VGND VGND VPWR VPWR soc_top_61/HI result1[4] sky130_fd_sc_hd__conb_1
Xsoc_top_50 VGND VGND VPWR VPWR soc_top_50/HI result1[14] sky130_fd_sc_hd__conb_1
XFILLER_6_60 VGND VGND VPWR VPWR sky130_fd_sc_hd__decap_3
XPHY_EDGE_ROW_7_Right_7 VGND VGND VPWR VPWR sky130_fd_sc_hd__decap_3
XFILLER_11_49 VGND VGND VPWR VPWR sky130_fd_sc_hd__decap_3
XFILLER_2_18 VGND VGND VPWR VPWR sky130_fd_sc_hd__decap_3
XFILLER_2_29 VGND VGND VPWR VPWR sky130_fd_sc_hd__decap_3
XTAP_TAPCELL_ROW_11_38 VGND VPWR sky130_fd_sc_hd__tapvpwrvgnd_1
X_12_ _29_/Q _12_/B VGND VGND VPWR VPWR _12_/Y sky130_fd_sc_hd__nor2_2
Xsoc_top_62 VGND VGND VPWR VPWR soc_top_62/HI result0[4] sky130_fd_sc_hd__conb_1
Xsoc_top_51 VGND VGND VPWR VPWR soc_top_51/HI result1[13] sky130_fd_sc_hd__conb_1
Xsoc_top_40 VGND VGND VPWR VPWR soc_top_40/HI result1[24] sky130_fd_sc_hd__conb_1
XFILLER_0_40 VGND VGND VPWR VPWR sky130_fd_sc_hd__decap_3
XFILLER_9_60 VGND VGND VPWR VPWR sky130_fd_sc_hd__decap_3
XFILLER_6_50 VGND VGND VPWR VPWR sky130_fd_sc_hd__fill_1
XFILLER_3_51 VGND VGND VPWR VPWR sky130_fd_sc_hd__decap_3
XFILLER_0_52 VGND VGND VPWR VPWR sky130_fd_sc_hd__fill_1
XFILLER_8_29 VGND VGND VPWR VPWR sky130_fd_sc_hd__decap_3
X_11_ _31_/Q _11_/B VGND VGND VPWR VPWR _12_/B sky130_fd_sc_hd__nand2b_2
Xsoc_top_63 VGND VGND VPWR VPWR soc_top_63/HI result1[3] sky130_fd_sc_hd__conb_1
Xsoc_top_52 VGND VGND VPWR VPWR soc_top_52/HI result1[12] sky130_fd_sc_hd__conb_1
Xsoc_top_41 VGND VGND VPWR VPWR soc_top_41/HI result1[23] sky130_fd_sc_hd__conb_1
Xsoc_top_30 VGND VGND VPWR VPWR soc_top_30/HI result0[8] sky130_fd_sc_hd__conb_1
XFILLER_3_30 VGND VGND VPWR VPWR sky130_fd_sc_hd__decap_3
XFILLER_3_63 VGND VGND VPWR VPWR sky130_fd_sc_hd__decap_3
XPHY_EDGE_ROW_5_Left_18 VGND VGND VPWR VPWR sky130_fd_sc_hd__decap_3
Xsoc_top_64 VGND VGND VPWR VPWR soc_top_64/HI result0[3] sky130_fd_sc_hd__conb_1
Xsoc_top_53 VGND VGND VPWR VPWR soc_top_53/HI result1[11] sky130_fd_sc_hd__conb_1
Xsoc_top_42 VGND VGND VPWR VPWR soc_top_42/HI result1[22] sky130_fd_sc_hd__conb_1
Xsoc_top_31 VGND VGND VPWR VPWR soc_top_31/HI result0[7] sky130_fd_sc_hd__conb_1
Xsoc_top_20 VGND VGND VPWR VPWR soc_top_20/HI result0[18] sky130_fd_sc_hd__conb_1
XPHY_EDGE_ROW_8_Left_21 VGND VGND VPWR VPWR sky130_fd_sc_hd__decap_3
XFILLER_6_63 VGND VGND VPWR VPWR sky130_fd_sc_hd__decap_3
Xhold70 _22_/Y VGND VGND VPWR VPWR _26_/D sky130_fd_sc_hd__dlygate4sd3_1
XFILLER_12_40 VGND VGND VPWR VPWR sky130_fd_sc_hd__decap_3
XTAP_TAPCELL_ROW_12_40 VGND VPWR sky130_fd_sc_hd__tapvpwrvgnd_1
Xsoc_top_65 VGND VGND VPWR VPWR soc_top_65/HI result0[1] sky130_fd_sc_hd__conb_1
Xsoc_top_54 VGND VGND VPWR VPWR soc_top_54/HI result1[10] sky130_fd_sc_hd__conb_1
Xsoc_top_43 VGND VGND VPWR VPWR soc_top_43/HI result1[21] sky130_fd_sc_hd__conb_1
Xsoc_top_32 VGND VGND VPWR VPWR soc_top_32/HI result0[6] sky130_fd_sc_hd__conb_1
Xsoc_top_21 VGND VGND VPWR VPWR soc_top_21/HI result0[17] sky130_fd_sc_hd__conb_1
Xsoc_top_10 VGND VGND VPWR VPWR soc_top_10/HI result0[28] sky130_fd_sc_hd__conb_1
XFILLER_9_63 VGND VGND VPWR VPWR sky130_fd_sc_hd__decap_3
Xoutput4 _17_/X VGND VGND VPWR VPWR result0[0] sky130_fd_sc_hd__clkdlybuf4s25_1
Xhold71 _31_/Q VGND VGND VPWR VPWR _21_/A sky130_fd_sc_hd__dlygate4sd3_1
XFILLER_3_21 VGND VGND VPWR VPWR sky130_fd_sc_hd__decap_3
XFILLER_3_54 VGND VGND VPWR VPWR sky130_fd_sc_hd__fill_2
XFILLER_0_22 VGND VGND VPWR VPWR sky130_fd_sc_hd__decap_3
XFILLER_9_53 VGND VGND VPWR VPWR sky130_fd_sc_hd__decap_3
XTAP_TAPCELL_ROW_5_32 VGND VPWR sky130_fd_sc_hd__tapvpwrvgnd_1
Xsoc_top_66 VGND VGND VPWR VPWR soc_top_66/HI result1[1] sky130_fd_sc_hd__conb_1
Xsoc_top_55 VGND VGND VPWR VPWR soc_top_55/HI result1[9] sky130_fd_sc_hd__conb_1
Xsoc_top_44 VGND VGND VPWR VPWR soc_top_44/HI result1[20] sky130_fd_sc_hd__conb_1
Xsoc_top_33 VGND VGND VPWR VPWR soc_top_33/HI result1[31] sky130_fd_sc_hd__conb_1
Xsoc_top_22 VGND VGND VPWR VPWR soc_top_22/HI result0[16] sky130_fd_sc_hd__conb_1
Xsoc_top_11 VGND VGND VPWR VPWR soc_top_11/HI result0[27] sky130_fd_sc_hd__conb_1
XFILLER_6_32 VGND VGND VPWR VPWR sky130_fd_sc_hd__fill_2
XPHY_EDGE_ROW_2_Right_2 VGND VGND VPWR VPWR sky130_fd_sc_hd__decap_3
Xhold72 _28_/Q VGND VGND VPWR VPWR _25_/A sky130_fd_sc_hd__dlygate4sd3_1
XFILLER_3_33 VGND VGND VPWR VPWR sky130_fd_sc_hd__decap_3
Xoutput5 _15_/Y VGND VGND VPWR VPWR result0[2] sky130_fd_sc_hd__clkdlybuf4s25_1
Xsoc_top_56 VGND VGND VPWR VPWR soc_top_56/HI result1[8] sky130_fd_sc_hd__conb_1
Xsoc_top_45 VGND VGND VPWR VPWR soc_top_45/HI result1[19] sky130_fd_sc_hd__conb_1
Xsoc_top_34 VGND VGND VPWR VPWR soc_top_34/HI result1[30] sky130_fd_sc_hd__conb_1
Xsoc_top_23 VGND VGND VPWR VPWR soc_top_23/HI result0[15] sky130_fd_sc_hd__conb_1
Xsoc_top_12 VGND VGND VPWR VPWR soc_top_12/HI result0[26] sky130_fd_sc_hd__conb_1
XFILLER_0_34 VGND VGND VPWR VPWR sky130_fd_sc_hd__decap_3
XFILLER_6_66 VGND VGND VPWR VPWR sky130_fd_sc_hd__decap_3
Xoutput6 _14_/X VGND VGND VPWR VPWR result1[0] sky130_fd_sc_hd__clkdlybuf4s25_1
Xhold73 _25_/Y VGND VGND VPWR VPWR _28_/D sky130_fd_sc_hd__dlygate4sd3_1
.ends
