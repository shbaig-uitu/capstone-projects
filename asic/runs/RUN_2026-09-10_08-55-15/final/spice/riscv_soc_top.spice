* NGSPICE file created from riscv_soc_top.ext - technology: sky130A

* Black-box entry subcircuit for sky130_fd_sc_hd__decap_3 abstract view
.subckt sky130_fd_sc_hd__decap_3 VGND VNB VPB VPWR
.ends

* Black-box entry subcircuit for sky130_fd_sc_hd__dfrtp_2 abstract view
.subckt sky130_fd_sc_hd__dfrtp_2 CLK D RESET_B VGND VNB VPB VPWR Q
.ends

* Black-box entry subcircuit for sky130_fd_sc_hd__and4_2 abstract view
.subckt sky130_fd_sc_hd__and4_2 A B C D VGND VNB VPB VPWR X
.ends

* Black-box entry subcircuit for sky130_fd_sc_hd__fill_1 abstract view
.subckt sky130_fd_sc_hd__fill_1 VGND VNB VPB VPWR
.ends

* Black-box entry subcircuit for sky130_fd_sc_hd__tapvpwrvgnd_1 abstract view
.subckt sky130_fd_sc_hd__tapvpwrvgnd_1 VGND VPWR
.ends

* Black-box entry subcircuit for sky130_fd_sc_hd__dlygate4sd3_1 abstract view
.subckt sky130_fd_sc_hd__dlygate4sd3_1 A VGND VNB VPB VPWR X
.ends

* Black-box entry subcircuit for sky130_fd_sc_hd__clkdlybuf4s25_1 abstract view
.subckt sky130_fd_sc_hd__clkdlybuf4s25_1 A VGND VNB VPB VPWR X
.ends

* Black-box entry subcircuit for sky130_fd_sc_hd__o21a_2 abstract view
.subckt sky130_fd_sc_hd__o21a_2 A1 A2 B1 VGND VNB VPB VPWR X
.ends

* Black-box entry subcircuit for sky130_fd_sc_hd__conb_1 abstract view
.subckt sky130_fd_sc_hd__conb_1 VGND VNB VPB VPWR HI LO
.ends

* Black-box entry subcircuit for sky130_fd_sc_hd__xnor2_2 abstract view
.subckt sky130_fd_sc_hd__xnor2_2 A B VGND VNB VPB VPWR Y
.ends

* Black-box entry subcircuit for sky130_fd_sc_hd__fill_2 abstract view
.subckt sky130_fd_sc_hd__fill_2 VGND VNB VPB VPWR
.ends

* Black-box entry subcircuit for sky130_fd_sc_hd__and2_2 abstract view
.subckt sky130_fd_sc_hd__and2_2 A B VGND VNB VPB VPWR X
.ends

* Black-box entry subcircuit for sky130_fd_sc_hd__or2_2 abstract view
.subckt sky130_fd_sc_hd__or2_2 A B VGND VNB VPB VPWR X
.ends

* Black-box entry subcircuit for sky130_fd_sc_hd__inv_4 abstract view
.subckt sky130_fd_sc_hd__inv_4 A VGND VNB VPB VPWR Y
.ends

* Black-box entry subcircuit for sky130_fd_sc_hd__nand2_2 abstract view
.subckt sky130_fd_sc_hd__nand2_2 A B VGND VNB VPB VPWR Y
.ends

* Black-box entry subcircuit for sky130_fd_sc_hd__clkbuf_4 abstract view
.subckt sky130_fd_sc_hd__clkbuf_4 A VGND VNB VPB VPWR X
.ends

* Black-box entry subcircuit for sky130_fd_sc_hd__a21oi_2 abstract view
.subckt sky130_fd_sc_hd__a21oi_2 A1 A2 B1 VGND VNB VPB VPWR Y
.ends

* Black-box entry subcircuit for sky130_fd_sc_hd__xor2_2 abstract view
.subckt sky130_fd_sc_hd__xor2_2 A B VGND VNB VPB VPWR X
.ends

* Black-box entry subcircuit for sky130_fd_sc_hd__o21ba_2 abstract view
.subckt sky130_fd_sc_hd__o21ba_2 A1 A2 B1_N VGND VNB VPB VPWR X
.ends

* Black-box entry subcircuit for sky130_fd_sc_hd__clkbuf_16 abstract view
.subckt sky130_fd_sc_hd__clkbuf_16 A VGND VNB VPB VPWR X
.ends

* Black-box entry subcircuit for sky130_fd_sc_hd__buf_2 abstract view
.subckt sky130_fd_sc_hd__buf_2 A VGND VNB VPB VPWR X
.ends

* Black-box entry subcircuit for sky130_fd_sc_hd__a31oi_2 abstract view
.subckt sky130_fd_sc_hd__a31oi_2 A1 A2 A3 B1 VGND VNB VPB VPWR Y
.ends

* Black-box entry subcircuit for sky130_fd_sc_hd__and3_2 abstract view
.subckt sky130_fd_sc_hd__and3_2 A B C VGND VNB VPB VPWR X
.ends

* Black-box entry subcircuit for sky130_fd_sc_hd__inv_2 abstract view
.subckt sky130_fd_sc_hd__inv_2 A VGND VNB VPB VPWR Y
.ends

* Black-box entry subcircuit for sky130_fd_sc_hd__a31o_2 abstract view
.subckt sky130_fd_sc_hd__a31o_2 A1 A2 A3 B1 VGND VNB VPB VPWR X
.ends

* Black-box entry subcircuit for sky130_fd_sc_hd__nor2_2 abstract view
.subckt sky130_fd_sc_hd__nor2_2 A B VGND VNB VPB VPWR Y
.ends

* Black-box entry subcircuit for sky130_fd_sc_hd__buf_12 abstract view
.subckt sky130_fd_sc_hd__buf_12 A VGND VNB VPB VPWR X
.ends

* Black-box entry subcircuit for sky130_fd_sc_hd__and2b_2 abstract view
.subckt sky130_fd_sc_hd__and2b_2 A_N B VGND VNB VPB VPWR X
.ends

* Black-box entry subcircuit for sky130_fd_sc_hd__buf_4 abstract view
.subckt sky130_fd_sc_hd__buf_4 A VGND VNB VPB VPWR X
.ends

* Black-box entry subcircuit for sky130_fd_sc_hd__o2bb2a_2 abstract view
.subckt sky130_fd_sc_hd__o2bb2a_2 A1_N A2_N B1 B2 VGND VNB VPB VPWR X
.ends

.subckt riscv_soc_top VGND VPWR axi_araddr[0] axi_araddr[10] axi_araddr[11] axi_araddr[12]
+ axi_araddr[13] axi_araddr[14] axi_araddr[15] axi_araddr[16] axi_araddr[17] axi_araddr[18]
+ axi_araddr[19] axi_araddr[1] axi_araddr[20] axi_araddr[21] axi_araddr[22] axi_araddr[23]
+ axi_araddr[24] axi_araddr[25] axi_araddr[26] axi_araddr[27] axi_araddr[28] axi_araddr[29]
+ axi_araddr[2] axi_araddr[30] axi_araddr[31] axi_araddr[3] axi_araddr[4] axi_araddr[5]
+ axi_araddr[6] axi_araddr[7] axi_araddr[8] axi_araddr[9] axi_arready axi_arvalid
+ axi_awaddr[0] axi_awaddr[10] axi_awaddr[11] axi_awaddr[12] axi_awaddr[13] axi_awaddr[14]
+ axi_awaddr[15] axi_awaddr[16] axi_awaddr[17] axi_awaddr[18] axi_awaddr[19] axi_awaddr[1]
+ axi_awaddr[20] axi_awaddr[21] axi_awaddr[22] axi_awaddr[23] axi_awaddr[24] axi_awaddr[25]
+ axi_awaddr[26] axi_awaddr[27] axi_awaddr[28] axi_awaddr[29] axi_awaddr[2] axi_awaddr[30]
+ axi_awaddr[31] axi_awaddr[3] axi_awaddr[4] axi_awaddr[5] axi_awaddr[6] axi_awaddr[7]
+ axi_awaddr[8] axi_awaddr[9] axi_awready axi_awvalid axi_bready axi_bresp[0] axi_bresp[1]
+ axi_bvalid axi_rdata[0] axi_rdata[10] axi_rdata[11] axi_rdata[12] axi_rdata[13]
+ axi_rdata[14] axi_rdata[15] axi_rdata[16] axi_rdata[17] axi_rdata[18] axi_rdata[19]
+ axi_rdata[1] axi_rdata[20] axi_rdata[21] axi_rdata[22] axi_rdata[23] axi_rdata[24]
+ axi_rdata[25] axi_rdata[26] axi_rdata[27] axi_rdata[28] axi_rdata[29] axi_rdata[2]
+ axi_rdata[30] axi_rdata[31] axi_rdata[3] axi_rdata[4] axi_rdata[5] axi_rdata[6]
+ axi_rdata[7] axi_rdata[8] axi_rdata[9] axi_rready axi_rresp[0] axi_rresp[1] axi_rvalid
+ axi_wdata[0] axi_wdata[10] axi_wdata[11] axi_wdata[12] axi_wdata[13] axi_wdata[14]
+ axi_wdata[15] axi_wdata[16] axi_wdata[17] axi_wdata[18] axi_wdata[19] axi_wdata[1]
+ axi_wdata[20] axi_wdata[21] axi_wdata[22] axi_wdata[23] axi_wdata[24] axi_wdata[25]
+ axi_wdata[26] axi_wdata[27] axi_wdata[28] axi_wdata[29] axi_wdata[2] axi_wdata[30]
+ axi_wdata[31] axi_wdata[3] axi_wdata[4] axi_wdata[5] axi_wdata[6] axi_wdata[7] axi_wdata[8]
+ axi_wdata[9] axi_wready axi_wstrb[0] axi_wstrb[1] axi_wstrb[2] axi_wstrb[3] axi_wvalid
+ clk ext_interrupt gpio_in[0] gpio_in[1] gpio_in[2] gpio_in[3] gpio_in[4] gpio_in[5]
+ gpio_in[6] gpio_in[7] gpio_out[0] gpio_out[1] gpio_out[2] gpio_out[3] gpio_out[4]
+ gpio_out[5] gpio_out[6] gpio_out[7] rst_n uart_rx uart_tx
XFILLER_13_144 VGND VGND VPWR VPWR sky130_fd_sc_hd__decap_3
XFILLER_3_12 VGND VGND VPWR VPWR sky130_fd_sc_hd__decap_3
XFILLER_10_136 VGND VGND VPWR VPWR sky130_fd_sc_hd__decap_3
X_200_ _226_/CLK _200_/D max_cap79/X VGND VGND VPWR VPWR _200_/Q sky130_fd_sc_hd__dfrtp_2
X_131_ _197_/Q _131_/B _131_/C _131_/D VGND VGND VPWR VPWR _166_/B sky130_fd_sc_hd__and4_2
XFILLER_0_57 VGND VGND VPWR VPWR sky130_fd_sc_hd__fill_1
XTAP_TAPCELL_ROW_18_97 VGND VPWR sky130_fd_sc_hd__tapvpwrvgnd_1
X_114_ _187_/Q _188_/Q _189_/Q _190_/Q VGND VGND VPWR VPWR _131_/B sky130_fd_sc_hd__and4_2
XFILLER_20_32 VGND VGND VPWR VPWR sky130_fd_sc_hd__fill_1
Xhold96 _217_/Q VGND VGND VPWR VPWR _183_/A sky130_fd_sc_hd__dlygate4sd3_1
Xhold85 _197_/Q VGND VGND VPWR VPWR _221_/D sky130_fd_sc_hd__dlygate4sd3_1
XFILLER_13_3 VGND VGND VPWR VPWR sky130_fd_sc_hd__decap_3
Xoutput42 _092_/X VGND VGND VPWR VPWR axi_rdata[14] sky130_fd_sc_hd__clkdlybuf4s25_1
Xoutput53 _102_/X VGND VGND VPWR VPWR axi_rdata[24] sky130_fd_sc_hd__clkdlybuf4s25_1
Xoutput64 _083_/X VGND VGND VPWR VPWR axi_rdata[5] sky130_fd_sc_hd__clkdlybuf4s25_1
Xoutput75 _224_/Q VGND VGND VPWR VPWR gpio_out[5] sky130_fd_sc_hd__clkdlybuf4s25_1
XTAP_TAPCELL_ROW_2_57 VGND VPWR sky130_fd_sc_hd__tapvpwrvgnd_1
XFILLER_22_123 VGND VGND VPWR VPWR sky130_fd_sc_hd__decap_3
XFILLER_3_57 VGND VGND VPWR VPWR sky130_fd_sc_hd__decap_3
X_130_ _126_/B _128_/Y _129_/X VGND VGND VPWR VPWR _196_/D sky130_fd_sc_hd__o21a_2
XPHY_EDGE_ROW_21_Right_21 VGND VGND VPWR VPWR sky130_fd_sc_hd__decap_3
XPHY_EDGE_ROW_12_Right_12 VGND VGND VPWR VPWR sky130_fd_sc_hd__decap_3
XFILLER_23_65 VGND VGND VPWR VPWR sky130_fd_sc_hd__decap_3
XFILLER_2_144 VGND VGND VPWR VPWR sky130_fd_sc_hd__decap_3
Xriscv_soc_top_80 VGND VGND VPWR VPWR riscv_soc_top_80/HI axi_rresp[0] sky130_fd_sc_hd__conb_1
XTAP_TAPCELL_ROW_18_98 VGND VPWR sky130_fd_sc_hd__tapvpwrvgnd_1
X_113_ _113_/A _113_/B VGND VGND VPWR VPWR _189_/D sky130_fd_sc_hd__xnor2_2
XPHY_EDGE_ROW_12_Left_37 VGND VGND VPWR VPWR sky130_fd_sc_hd__decap_3
XFILLER_20_11 VGND VGND VPWR VPWR sky130_fd_sc_hd__decap_3
Xhold97 _208_/Q VGND VGND VPWR VPWR hold97/X sky130_fd_sc_hd__dlygate4sd3_1
Xhold86 _202_/Q VGND VGND VPWR VPWR _226_/D sky130_fd_sc_hd__dlygate4sd3_1
XPHY_EDGE_ROW_6_Right_6 VGND VGND VPWR VPWR sky130_fd_sc_hd__decap_3
Xoutput43 _093_/X VGND VGND VPWR VPWR axi_rdata[15] sky130_fd_sc_hd__clkdlybuf4s25_1
Xoutput54 _103_/X VGND VGND VPWR VPWR axi_rdata[25] sky130_fd_sc_hd__clkdlybuf4s25_1
Xoutput65 _084_/X VGND VGND VPWR VPWR axi_rdata[6] sky130_fd_sc_hd__clkdlybuf4s25_1
Xoutput76 _225_/Q VGND VGND VPWR VPWR gpio_out[6] sky130_fd_sc_hd__clkdlybuf4s25_1
XTAP_TAPCELL_ROW_2_58 VGND VPWR sky130_fd_sc_hd__tapvpwrvgnd_1
XFILLER_22_135 VGND VGND VPWR VPWR sky130_fd_sc_hd__decap_3
XPHY_EDGE_ROW_15_Left_40 VGND VGND VPWR VPWR sky130_fd_sc_hd__decap_3
XFILLER_12_56 VGND VGND VPWR VPWR sky130_fd_sc_hd__decap_3
XPHY_EDGE_ROW_0_Left_25 VGND VGND VPWR VPWR sky130_fd_sc_hd__decap_3
XFILLER_23_11 VGND VGND VPWR VPWR sky130_fd_sc_hd__decap_3
XFILLER_9_24 VGND VGND VPWR VPWR sky130_fd_sc_hd__fill_1
Xriscv_soc_top_81 VGND VGND VPWR VPWR riscv_soc_top_81/HI axi_rresp[1] sky130_fd_sc_hd__conb_1
XFILLER_9_57 VGND VGND VPWR VPWR sky130_fd_sc_hd__fill_2
X_189_ _220_/CLK _189_/D input33/X VGND VGND VPWR VPWR _189_/Q sky130_fd_sc_hd__dfrtp_2
XTAP_TAPCELL_ROW_18_99 VGND VPWR sky130_fd_sc_hd__tapvpwrvgnd_1
XFILLER_18_44 VGND VGND VPWR VPWR sky130_fd_sc_hd__decap_3
X_112_ _113_/B _112_/B VGND VGND VPWR VPWR _188_/D sky130_fd_sc_hd__and2_2
XFILLER_22_9 VGND VGND VPWR VPWR sky130_fd_sc_hd__fill_2
XFILLER_1_80 VGND VGND VPWR VPWR sky130_fd_sc_hd__decap_3
XFILLER_1_91 VGND VGND VPWR VPWR sky130_fd_sc_hd__fill_2
XFILLER_20_23 VGND VGND VPWR VPWR sky130_fd_sc_hd__decap_3
Xhold98 _192_/Q VGND VGND VPWR VPWR _119_/A sky130_fd_sc_hd__dlygate4sd3_1
Xhold87 _196_/Q VGND VGND VPWR VPWR _220_/D sky130_fd_sc_hd__dlygate4sd3_1
XFILLER_16_144 VGND VGND VPWR VPWR sky130_fd_sc_hd__decap_3
Xoutput44 _094_/X VGND VGND VPWR VPWR axi_rdata[16] sky130_fd_sc_hd__clkdlybuf4s25_1
Xoutput55 _104_/X VGND VGND VPWR VPWR axi_rdata[26] sky130_fd_sc_hd__clkdlybuf4s25_1
Xoutput66 _085_/X VGND VGND VPWR VPWR axi_rdata[7] sky130_fd_sc_hd__clkdlybuf4s25_1
Xoutput77 _226_/Q VGND VGND VPWR VPWR gpio_out[7] sky130_fd_sc_hd__clkdlybuf4s25_1
XTAP_TAPCELL_ROW_2_59 VGND VPWR sky130_fd_sc_hd__tapvpwrvgnd_1
XFILLER_22_114 VGND VGND VPWR VPWR sky130_fd_sc_hd__decap_3
XFILLER_3_15 VGND VGND VPWR VPWR sky130_fd_sc_hd__decap_3
XFILLER_10_139 VGND VGND VPWR VPWR sky130_fd_sc_hd__fill_1
XFILLER_2_135 VGND VGND VPWR VPWR sky130_fd_sc_hd__decap_3
Xriscv_soc_top_82 VGND VGND VPWR VPWR riscv_soc_top_82/HI axi_bresp[0] sky130_fd_sc_hd__conb_1
X_188_ _220_/CLK _188_/D input33/X VGND VGND VPWR VPWR _188_/Q sky130_fd_sc_hd__dfrtp_2
X_111_ _187_/Q _188_/Q VGND VGND VPWR VPWR _112_/B sky130_fd_sc_hd__or2_2
Xhold99 _189_/Q VGND VGND VPWR VPWR _113_/A sky130_fd_sc_hd__dlygate4sd3_1
Xhold88 _200_/Q VGND VGND VPWR VPWR _224_/D sky130_fd_sc_hd__dlygate4sd3_1
XFILLER_13_6 VGND VGND VPWR VPWR sky130_fd_sc_hd__fill_1
Xoutput45 _095_/X VGND VGND VPWR VPWR axi_rdata[17] sky130_fd_sc_hd__clkdlybuf4s25_1
Xoutput56 _105_/X VGND VGND VPWR VPWR axi_rdata[27] sky130_fd_sc_hd__clkdlybuf4s25_1
Xoutput67 _086_/X VGND VGND VPWR VPWR axi_rdata[8] sky130_fd_sc_hd__clkdlybuf4s25_1
Xoutput78 _186_/Q VGND VGND VPWR VPWR uart_tx sky130_fd_sc_hd__clkdlybuf4s25_1
XFILLER_11_3 VGND VGND VPWR VPWR sky130_fd_sc_hd__fill_1
XFILLER_22_126 VGND VGND VPWR VPWR sky130_fd_sc_hd__decap_3
XTAP_TAPCELL_ROW_23_110 VGND VPWR sky130_fd_sc_hd__tapvpwrvgnd_1
XFILLER_8_141 VGND VGND VPWR VPWR sky130_fd_sc_hd__decap_3
XTAP_TAPCELL_ROW_20_102 VGND VPWR sky130_fd_sc_hd__tapvpwrvgnd_1
XFILLER_5_111 VGND VGND VPWR VPWR sky130_fd_sc_hd__fill_1
XFILLER_23_68 VGND VGND VPWR VPWR sky130_fd_sc_hd__fill_1
XFILLER_4_81 VGND VGND VPWR VPWR sky130_fd_sc_hd__decap_3
XFILLER_13_90 VGND VGND VPWR VPWR sky130_fd_sc_hd__decap_3
Xriscv_soc_top_83 VGND VGND VPWR VPWR axi_bvalid riscv_soc_top_83/LO sky130_fd_sc_hd__conb_1
X_187_ _220_/CLK _187_/D input33/X VGND VGND VPWR VPWR _187_/Q sky130_fd_sc_hd__dfrtp_2
Xclkload0 _223_/CLK VGND VGND VPWR VPWR clkload0/Y sky130_fd_sc_hd__inv_4
X_110_ _187_/Q _188_/Q VGND VGND VPWR VPWR _113_/B sky130_fd_sc_hd__nand2_2
XFILLER_1_60 VGND VGND VPWR VPWR sky130_fd_sc_hd__decap_3
XFILLER_20_14 VGND VGND VPWR VPWR sky130_fd_sc_hd__decap_3
Xhold89 _198_/Q VGND VGND VPWR VPWR _222_/D sky130_fd_sc_hd__dlygate4sd3_1
Xoutput35 _233_/X VGND VGND VPWR VPWR axi_arready sky130_fd_sc_hd__clkdlybuf4s25_1
Xoutput46 _096_/X VGND VGND VPWR VPWR axi_rdata[18] sky130_fd_sc_hd__clkdlybuf4s25_1
Xoutput57 _106_/X VGND VGND VPWR VPWR axi_rdata[28] sky130_fd_sc_hd__clkdlybuf4s25_1
XFILLER_16_135 VGND VGND VPWR VPWR sky130_fd_sc_hd__decap_3
Xoutput68 _087_/X VGND VGND VPWR VPWR axi_rdata[9] sky130_fd_sc_hd__clkdlybuf4s25_1
XPHY_EDGE_ROW_19_Right_19 VGND VGND VPWR VPWR sky130_fd_sc_hd__decap_3
XFILLER_22_138 VGND VGND VPWR VPWR sky130_fd_sc_hd__fill_2
XTAP_TAPCELL_ROW_23_111 VGND VPWR sky130_fd_sc_hd__tapvpwrvgnd_1
XTAP_TAPCELL_ROW_3_60 VGND VPWR sky130_fd_sc_hd__tapvpwrvgnd_1
XPHY_EDGE_ROW_19_Left_44 VGND VGND VPWR VPWR sky130_fd_sc_hd__decap_3
XFILLER_12_59 VGND VGND VPWR VPWR sky130_fd_sc_hd__decap_3
XTAP_TAPCELL_ROW_20_103 VGND VPWR sky130_fd_sc_hd__tapvpwrvgnd_1
XFILLER_23_14 VGND VGND VPWR VPWR sky130_fd_sc_hd__decap_3
XPHY_EDGE_ROW_4_Left_29 VGND VGND VPWR VPWR sky130_fd_sc_hd__decap_3
XFILLER_0_29 VGND VGND VPWR VPWR sky130_fd_sc_hd__decap_3
XFILLER_3_6 VGND VGND VPWR VPWR sky130_fd_sc_hd__decap_3
Xriscv_soc_top_84 VGND VGND VPWR VPWR axi_rvalid riscv_soc_top_84/LO sky130_fd_sc_hd__conb_1
X_186_ _220_/CLK _186_/D input33/X VGND VGND VPWR VPWR _186_/Q sky130_fd_sc_hd__dfrtp_2
XTAP_TAPCELL_ROW_0_50 VGND VPWR sky130_fd_sc_hd__tapvpwrvgnd_1
XFILLER_18_47 VGND VGND VPWR VPWR sky130_fd_sc_hd__decap_3
XFILLER_1_3 VGND VGND VPWR VPWR sky130_fd_sc_hd__decap_3
Xclkload1 _220_/CLK VGND VGND VPWR VPWR clkload1/X sky130_fd_sc_hd__clkbuf_4
X_169_ _211_/Q _182_/B _212_/Q VGND VGND VPWR VPWR _171_/A sky130_fd_sc_hd__a21oi_2
XFILLER_20_26 VGND VGND VPWR VPWR sky130_fd_sc_hd__fill_2
XFILLER_19_144 VGND VGND VPWR VPWR sky130_fd_sc_hd__decap_3
XPHY_EDGE_ROW_7_Left_32 VGND VGND VPWR VPWR sky130_fd_sc_hd__decap_3
Xoutput36 _234_/X VGND VGND VPWR VPWR axi_awready sky130_fd_sc_hd__clkdlybuf4s25_1
Xoutput47 _097_/X VGND VGND VPWR VPWR axi_rdata[19] sky130_fd_sc_hd__clkdlybuf4s25_1
Xoutput58 _107_/X VGND VGND VPWR VPWR axi_rdata[29] sky130_fd_sc_hd__clkdlybuf4s25_1
Xoutput69 _235_/X VGND VGND VPWR VPWR axi_wready sky130_fd_sc_hd__clkdlybuf4s25_1
XFILLER_22_117 VGND VGND VPWR VPWR sky130_fd_sc_hd__decap_3
XFILLER_3_18 VGND VGND VPWR VPWR sky130_fd_sc_hd__decap_3
XTAP_TAPCELL_ROW_3_61 VGND VPWR sky130_fd_sc_hd__tapvpwrvgnd_1
XTAP_TAPCELL_ROW_20_104 VGND VPWR sky130_fd_sc_hd__tapvpwrvgnd_1
XFILLER_5_113 VGND VGND VPWR VPWR sky130_fd_sc_hd__decap_3
XPHY_EDGE_ROW_20_Left_45 VGND VGND VPWR VPWR sky130_fd_sc_hd__decap_3
XFILLER_13_81 VGND VGND VPWR VPWR sky130_fd_sc_hd__decap_3
XFILLER_2_138 VGND VGND VPWR VPWR sky130_fd_sc_hd__fill_2
X_185_ _185_/A _185_/B VGND VGND VPWR VPWR _186_/D sky130_fd_sc_hd__xor2_2
XTAP_TAPCELL_ROW_0_51 VGND VPWR sky130_fd_sc_hd__tapvpwrvgnd_1
Xclkload2 _214_/CLK VGND VGND VPWR VPWR clkload2/Y sky130_fd_sc_hd__inv_4
X_168_ _211_/Q _182_/B VGND VGND VPWR VPWR _211_/D sky130_fd_sc_hd__xor2_2
X_099_ _208_/Q _099_/B VGND VGND VPWR VPWR _099_/X sky130_fd_sc_hd__xor2_2
XFILLER_1_51 VGND VGND VPWR VPWR sky130_fd_sc_hd__decap_3
XFILLER_10_93 VGND VGND VPWR VPWR sky130_fd_sc_hd__fill_1
Xoutput37 _078_/X VGND VGND VPWR VPWR axi_rdata[0] sky130_fd_sc_hd__clkdlybuf4s25_1
Xoutput48 _079_/X VGND VGND VPWR VPWR axi_rdata[1] sky130_fd_sc_hd__clkdlybuf4s25_1
Xoutput59 _080_/X VGND VGND VPWR VPWR axi_rdata[2] sky130_fd_sc_hd__clkdlybuf4s25_1
XPHY_EDGE_ROW_1_Right_1 VGND VGND VPWR VPWR sky130_fd_sc_hd__decap_3
XFILLER_21_81 VGND VGND VPWR VPWR sky130_fd_sc_hd__fill_1
XFILLER_22_129 VGND VGND VPWR VPWR sky130_fd_sc_hd__decap_3
XFILLER_13_129 VGND VGND VPWR VPWR sky130_fd_sc_hd__fill_2
XTAP_TAPCELL_ROW_16_92 VGND VPWR sky130_fd_sc_hd__tapvpwrvgnd_1
XFILLER_8_144 VGND VGND VPWR VPWR sky130_fd_sc_hd__decap_3
Xhold100 _204_/Q VGND VGND VPWR VPWR _148_/A sky130_fd_sc_hd__dlygate4sd3_1
XFILLER_5_125 VGND VGND VPWR VPWR sky130_fd_sc_hd__fill_1
XFILLER_13_60 VGND VGND VPWR VPWR sky130_fd_sc_hd__decap_3
XFILLER_13_93 VGND VGND VPWR VPWR sky130_fd_sc_hd__decap_3
X_184_ _184_/A _184_/B VGND VGND VPWR VPWR _218_/D sky130_fd_sc_hd__xor2_2
XTAP_TAPCELL_ROW_0_52 VGND VPWR sky130_fd_sc_hd__tapvpwrvgnd_1
XFILLER_18_38 VGND VGND VPWR VPWR sky130_fd_sc_hd__decap_3
X_167_ _210_/Q _161_/B _182_/B VGND VGND VPWR VPWR _210_/D sky130_fd_sc_hd__o21ba_2
X_098_ _207_/Q _098_/B VGND VGND VPWR VPWR _098_/X sky130_fd_sc_hd__xor2_2
XFILLER_1_63 VGND VGND VPWR VPWR sky130_fd_sc_hd__fill_1
XFILLER_20_17 VGND VGND VPWR VPWR sky130_fd_sc_hd__decap_3
XFILLER_19_113 VGND VGND VPWR VPWR sky130_fd_sc_hd__fill_2
XFILLER_6_19 VGND VGND VPWR VPWR sky130_fd_sc_hd__fill_1
X_219_ _220_/CLK _219_/D max_cap79/X VGND VGND VPWR VPWR _219_/Q sky130_fd_sc_hd__dfrtp_2
XFILLER_16_138 VGND VGND VPWR VPWR sky130_fd_sc_hd__fill_2
Xoutput38 _088_/X VGND VGND VPWR VPWR axi_rdata[10] sky130_fd_sc_hd__clkdlybuf4s25_1
Xoutput49 _098_/X VGND VGND VPWR VPWR axi_rdata[20] sky130_fd_sc_hd__clkdlybuf4s25_1
Xclkbuf_0_clk clk VGND VGND VPWR VPWR clkbuf_0_clk/X sky130_fd_sc_hd__clkbuf_16
XPHY_EDGE_ROW_24_Right_24 VGND VGND VPWR VPWR sky130_fd_sc_hd__decap_3
XPHY_EDGE_ROW_15_Right_15 VGND VGND VPWR VPWR sky130_fd_sc_hd__decap_3
XFILLER_12_141 VGND VGND VPWR VPWR sky130_fd_sc_hd__decap_3
XTAP_TAPCELL_ROW_16_93 VGND VPWR sky130_fd_sc_hd__tapvpwrvgnd_1
Xhold101 _194_/Q VGND VGND VPWR VPWR _125_/A1 sky130_fd_sc_hd__dlygate4sd3_1
XFILLER_4_85 VGND VGND VPWR VPWR sky130_fd_sc_hd__fill_1
XFILLER_23_17 VGND VGND VPWR VPWR sky130_fd_sc_hd__fill_2
XFILLER_3_9 VGND VGND VPWR VPWR sky130_fd_sc_hd__decap_3
XFILLER_13_72 VGND VGND VPWR VPWR sky130_fd_sc_hd__decap_3
X_183_ _183_/A _183_/B VGND VGND VPWR VPWR _217_/D sky130_fd_sc_hd__xor2_2
XTAP_TAPCELL_ROW_0_53 VGND VPWR sky130_fd_sc_hd__tapvpwrvgnd_1
XFILLER_1_6 VGND VGND VPWR VPWR sky130_fd_sc_hd__decap_3
X_235_ axi_wvalid VGND VGND VPWR VPWR _235_/X sky130_fd_sc_hd__buf_2
XFILLER_20_29 VGND VGND VPWR VPWR sky130_fd_sc_hd__decap_3
X_166_ _198_/Q _166_/B _166_/C _166_/D VGND VGND VPWR VPWR _180_/A sky130_fd_sc_hd__and4_2
X_097_ _206_/Q _097_/B VGND VGND VPWR VPWR _097_/X sky130_fd_sc_hd__xor2_2
XFILLER_19_103 VGND VGND VPWR VPWR sky130_fd_sc_hd__decap_3
X_218_ _220_/CLK _218_/D max_cap79/X VGND VGND VPWR VPWR _218_/Q sky130_fd_sc_hd__dfrtp_2
X_149_ _203_/Q _204_/Q _150_/D _205_/Q VGND VGND VPWR VPWR _151_/A sky130_fd_sc_hd__a31oi_2
Xoutput39 _089_/X VGND VGND VPWR VPWR axi_rdata[11] sky130_fd_sc_hd__clkdlybuf4s25_1
XTAP_TAPCELL_ROW_16_94 VGND VPWR sky130_fd_sc_hd__tapvpwrvgnd_1
XFILLER_5_116 VGND VGND VPWR VPWR sky130_fd_sc_hd__fill_1
Xhold102 _216_/Q VGND VGND VPWR VPWR _181_/A1 sky130_fd_sc_hd__dlygate4sd3_1
Xclkbuf_2_0__f_clk clkbuf_0_clk/X VGND VGND VPWR VPWR _223_/CLK sky130_fd_sc_hd__clkbuf_16
XFILLER_13_84 VGND VGND VPWR VPWR sky130_fd_sc_hd__decap_3
X_182_ _217_/Q _182_/B _182_/C _182_/D VGND VGND VPWR VPWR _184_/B sky130_fd_sc_hd__and4_2
XTAP_TAPCELL_ROW_0_54 VGND VPWR sky130_fd_sc_hd__tapvpwrvgnd_1
XPHY_EDGE_ROW_24_Left_49 VGND VGND VPWR VPWR sky130_fd_sc_hd__decap_3
XFILLER_18_29 VGND VGND VPWR VPWR sky130_fd_sc_hd__fill_1
XFILLER_1_54 VGND VGND VPWR VPWR sky130_fd_sc_hd__fill_2
X_234_ axi_awvalid VGND VGND VPWR VPWR _234_/X sky130_fd_sc_hd__buf_2
X_165_ _209_/Q _210_/Q _165_/C _165_/D VGND VGND VPWR VPWR _166_/D sky130_fd_sc_hd__and4_2
X_096_ _205_/Q _096_/B VGND VGND VPWR VPWR _096_/X sky130_fd_sc_hd__xor2_2
X_217_ _220_/CLK _217_/D max_cap79/X VGND VGND VPWR VPWR _217_/Q sky130_fd_sc_hd__dfrtp_2
X_148_ _148_/A _148_/B VGND VGND VPWR VPWR _204_/D sky130_fd_sc_hd__xnor2_2
X_079_ _188_/Q _079_/B VGND VGND VPWR VPWR _079_/X sky130_fd_sc_hd__xor2_2
XPHY_EDGE_ROW_11_Left_36 VGND VGND VPWR VPWR sky130_fd_sc_hd__decap_3
XFILLER_7_31 VGND VGND VPWR VPWR sky130_fd_sc_hd__decap_3
XFILLER_7_53 VGND VGND VPWR VPWR sky130_fd_sc_hd__decap_3
XPHY_EDGE_ROW_5_Right_5 VGND VGND VPWR VPWR sky130_fd_sc_hd__decap_3
Xhold103 _206_/Q VGND VGND VPWR VPWR _154_/A1 sky130_fd_sc_hd__dlygate4sd3_1
XFILLER_4_21 VGND VGND VPWR VPWR sky130_fd_sc_hd__decap_3
XFILLER_13_52 VGND VGND VPWR VPWR sky130_fd_sc_hd__decap_3
XFILLER_13_63 VGND VGND VPWR VPWR sky130_fd_sc_hd__decap_3
X_181_ _181_/A1 _178_/B _183_/B VGND VGND VPWR VPWR _216_/D sky130_fd_sc_hd__o21ba_2
XTAP_TAPCELL_ROW_13_85 VGND VPWR sky130_fd_sc_hd__tapvpwrvgnd_1
XTAP_TAPCELL_ROW_9_75 VGND VPWR sky130_fd_sc_hd__tapvpwrvgnd_1
XFILLER_1_77 VGND VGND VPWR VPWR sky130_fd_sc_hd__decap_3
X_233_ axi_arvalid VGND VGND VPWR VPWR _233_/X sky130_fd_sc_hd__buf_2
X_164_ _198_/Q _166_/B _166_/C _164_/D VGND VGND VPWR VPWR _182_/B sky130_fd_sc_hd__and4_2
X_095_ _204_/Q _095_/B VGND VGND VPWR VPWR _095_/X sky130_fd_sc_hd__xor2_2
X_216_ _220_/CLK _216_/D max_cap79/X VGND VGND VPWR VPWR _216_/Q sky130_fd_sc_hd__dfrtp_2
X_147_ _203_/Q _150_/D VGND VGND VPWR VPWR _203_/D sky130_fd_sc_hd__xor2_2
X_078_ _187_/Q _078_/B VGND VGND VPWR VPWR _078_/X sky130_fd_sc_hd__xor2_2
XFILLER_24_141 VGND VGND VPWR VPWR sky130_fd_sc_hd__decap_3
XFILLER_21_111 VGND VGND VPWR VPWR sky130_fd_sc_hd__fill_1
XFILLER_21_122 VGND VGND VPWR VPWR sky130_fd_sc_hd__decap_3
XFILLER_12_144 VGND VGND VPWR VPWR sky130_fd_sc_hd__decap_3
XPHY_EDGE_ROW_20_Right_20 VGND VGND VPWR VPWR sky130_fd_sc_hd__decap_3
XPHY_EDGE_ROW_11_Right_11 VGND VGND VPWR VPWR sky130_fd_sc_hd__decap_3
Xhold104 _207_/Q VGND VGND VPWR VPWR _155_/A sky130_fd_sc_hd__dlygate4sd3_1
XFILLER_13_42 VGND VGND VPWR VPWR sky130_fd_sc_hd__fill_2
XFILLER_13_75 VGND VGND VPWR VPWR sky130_fd_sc_hd__decap_3
X_180_ _180_/A _182_/C _182_/D VGND VGND VPWR VPWR _183_/B sky130_fd_sc_hd__and3_2
XTAP_TAPCELL_ROW_13_86 VGND VPWR sky130_fd_sc_hd__tapvpwrvgnd_1
XTAP_TAPCELL_ROW_9_76 VGND VPWR sky130_fd_sc_hd__tapvpwrvgnd_1
XFILLER_1_9 VGND VGND VPWR VPWR sky130_fd_sc_hd__decap_3
XFILLER_1_12 VGND VGND VPWR VPWR sky130_fd_sc_hd__fill_2
X_163_ _207_/Q _165_/C _163_/C VGND VGND VPWR VPWR _164_/D sky130_fd_sc_hd__and3_2
X_094_ _203_/Q _094_/B VGND VGND VPWR VPWR _094_/X sky130_fd_sc_hd__xor2_2
XFILLER_10_32 VGND VGND VPWR VPWR sky130_fd_sc_hd__decap_3
XFILLER_10_43 VGND VGND VPWR VPWR sky130_fd_sc_hd__decap_3
XFILLER_19_106 VGND VGND VPWR VPWR sky130_fd_sc_hd__decap_3
XFILLER_19_74 VGND VGND VPWR VPWR sky130_fd_sc_hd__fill_1
X_215_ _220_/CLK _215_/D max_cap79/X VGND VGND VPWR VPWR _215_/Q sky130_fd_sc_hd__dfrtp_2
X_146_ _203_/Q _150_/D VGND VGND VPWR VPWR _148_/B sky130_fd_sc_hd__nand2_2
X_077_ _077_/A VGND VGND VPWR VPWR _187_/D sky130_fd_sc_hd__inv_2
XFILLER_21_20 VGND VGND VPWR VPWR sky130_fd_sc_hd__fill_2
X_129_ _195_/Q _131_/B _131_/C _196_/Q VGND VGND VPWR VPWR _129_/X sky130_fd_sc_hd__a31o_2
XFILLER_4_12 VGND VGND VPWR VPWR sky130_fd_sc_hd__decap_3
XFILLER_4_141 VGND VGND VPWR VPWR sky130_fd_sc_hd__decap_3
XFILLER_13_87 VGND VGND VPWR VPWR sky130_fd_sc_hd__decap_3
XFILLER_8_3 VGND VGND VPWR VPWR sky130_fd_sc_hd__decap_3
X_162_ _208_/Q _209_/Q _210_/Q VGND VGND VPWR VPWR _163_/C sky130_fd_sc_hd__and3_2
X_093_ _202_/Q _093_/B VGND VGND VPWR VPWR _093_/X sky130_fd_sc_hd__xor2_2
XFILLER_1_57 VGND VGND VPWR VPWR sky130_fd_sc_hd__decap_3
Xinput1 axi_araddr[0] VGND VGND VPWR VPWR _078_/B sky130_fd_sc_hd__clkdlybuf4s25_1
XTAP_TAPCELL_ROW_10_77 VGND VPWR sky130_fd_sc_hd__tapvpwrvgnd_1
X_214_ _214_/CLK _214_/D max_cap79/X VGND VGND VPWR VPWR _214_/Q sky130_fd_sc_hd__dfrtp_2
X_145_ _202_/Q _141_/X _150_/D VGND VGND VPWR VPWR _202_/D sky130_fd_sc_hd__o21ba_2
XTAP_TAPCELL_ROW_6_67 VGND VPWR sky130_fd_sc_hd__tapvpwrvgnd_1
XFILLER_24_132 VGND VGND VPWR VPWR sky130_fd_sc_hd__decap_3
XFILLER_7_34 VGND VGND VPWR VPWR sky130_fd_sc_hd__decap_3
X_128_ _195_/Q _196_/Q VGND VGND VPWR VPWR _128_/Y sky130_fd_sc_hd__nand2_2
XPHY_EDGE_ROW_9_Right_9 VGND VGND VPWR VPWR sky130_fd_sc_hd__decap_3
XFILLER_4_24 VGND VGND VPWR VPWR sky130_fd_sc_hd__decap_3
XPHY_EDGE_ROW_18_Left_43 VGND VGND VPWR VPWR sky130_fd_sc_hd__decap_3
XFILLER_13_33 VGND VGND VPWR VPWR sky130_fd_sc_hd__fill_1
XFILLER_13_55 VGND VGND VPWR VPWR sky130_fd_sc_hd__fill_1
XFILLER_13_66 VGND VGND VPWR VPWR sky130_fd_sc_hd__decap_3
XFILLER_24_32 VGND VGND VPWR VPWR sky130_fd_sc_hd__decap_3
X_161_ _161_/A _161_/B VGND VGND VPWR VPWR _209_/D sky130_fd_sc_hd__nor2_2
XPHY_EDGE_ROW_3_Left_28 VGND VGND VPWR VPWR sky130_fd_sc_hd__decap_3
X_092_ _201_/Q _092_/B VGND VGND VPWR VPWR _092_/X sky130_fd_sc_hd__xor2_2
XFILLER_10_67 VGND VGND VPWR VPWR sky130_fd_sc_hd__decap_3
Xinput2 axi_araddr[10] VGND VGND VPWR VPWR _088_/B sky130_fd_sc_hd__clkdlybuf4s25_1
XTAP_TAPCELL_ROW_10_78 VGND VPWR sky130_fd_sc_hd__tapvpwrvgnd_1
XFILLER_19_32 VGND VGND VPWR VPWR sky130_fd_sc_hd__decap_3
XFILLER_19_43 VGND VGND VPWR VPWR sky130_fd_sc_hd__fill_2
X_213_ _214_/CLK _213_/D max_cap79/X VGND VGND VPWR VPWR _213_/Q sky130_fd_sc_hd__dfrtp_2
X_144_ _198_/Q _166_/B _166_/C VGND VGND VPWR VPWR _150_/D sky130_fd_sc_hd__and3_2
XTAP_TAPCELL_ROW_6_68 VGND VPWR sky130_fd_sc_hd__tapvpwrvgnd_1
XFILLER_18_141 VGND VGND VPWR VPWR sky130_fd_sc_hd__decap_3
XFILLER_21_11 VGND VGND VPWR VPWR sky130_fd_sc_hd__decap_3
XFILLER_24_144 VGND VGND VPWR VPWR sky130_fd_sc_hd__decap_3
XPHY_EDGE_ROW_6_Left_31 VGND VGND VPWR VPWR sky130_fd_sc_hd__decap_3
X_127_ _195_/Q _196_/Q VGND VGND VPWR VPWR _131_/D sky130_fd_sc_hd__and2_2
XFILLER_21_125 VGND VGND VPWR VPWR sky130_fd_sc_hd__decap_3
XFILLER_13_78 VGND VGND VPWR VPWR sky130_fd_sc_hd__decap_3
XFILLER_1_146 VGND VGND VPWR VPWR sky130_fd_sc_hd__fill_1
X_160_ _209_/Q _160_/B _165_/D VGND VGND VPWR VPWR _161_/B sky130_fd_sc_hd__and3_2
X_091_ _200_/Q _091_/B VGND VGND VPWR VPWR _091_/X sky130_fd_sc_hd__xor2_2
Xinput3 axi_araddr[11] VGND VGND VPWR VPWR _089_/B sky130_fd_sc_hd__clkdlybuf4s25_1
XTAP_TAPCELL_ROW_10_79 VGND VPWR sky130_fd_sc_hd__tapvpwrvgnd_1
XPHY_EDGE_ROW_18_Right_18 VGND VGND VPWR VPWR sky130_fd_sc_hd__decap_3
XFILLER_19_109 VGND VGND VPWR VPWR sky130_fd_sc_hd__decap_3
XFILLER_19_55 VGND VGND VPWR VPWR sky130_fd_sc_hd__fill_1
X_212_ _214_/CLK _212_/D max_cap79/X VGND VGND VPWR VPWR _212_/Q sky130_fd_sc_hd__dfrtp_2
X_143_ _199_/Q _200_/Q _201_/Q _202_/Q VGND VGND VPWR VPWR _166_/C sky130_fd_sc_hd__and4_2
XTAP_TAPCELL_ROW_6_69 VGND VPWR sky130_fd_sc_hd__tapvpwrvgnd_1
XFILLER_21_78 VGND VGND VPWR VPWR sky130_fd_sc_hd__decap_3
X_126_ _195_/Q _126_/B VGND VGND VPWR VPWR _195_/D sky130_fd_sc_hd__xnor2_2
XPHY_EDGE_ROW_0_Right_0 VGND VGND VPWR VPWR sky130_fd_sc_hd__decap_3
X_109_ _218_/Q _109_/B VGND VGND VPWR VPWR _109_/X sky130_fd_sc_hd__xor2_2
XFILLER_4_144 VGND VGND VPWR VPWR sky130_fd_sc_hd__decap_3
XFILLER_4_15 VGND VGND VPWR VPWR sky130_fd_sc_hd__decap_3
XFILLER_13_57 VGND VGND VPWR VPWR sky130_fd_sc_hd__decap_3
XFILLER_8_6 VGND VGND VPWR VPWR sky130_fd_sc_hd__fill_1
XFILLER_5_80 VGND VGND VPWR VPWR sky130_fd_sc_hd__fill_2
X_090_ _199_/Q _090_/B VGND VGND VPWR VPWR _090_/X sky130_fd_sc_hd__xor2_2
Xinput4 axi_araddr[12] VGND VGND VPWR VPWR _090_/B sky130_fd_sc_hd__clkdlybuf4s25_1
Xclkbuf_2_1__f_clk clkbuf_0_clk/X VGND VGND VPWR VPWR _220_/CLK sky130_fd_sc_hd__clkbuf_16
XFILLER_10_25 VGND VGND VPWR VPWR sky130_fd_sc_hd__decap_3
X_211_ _214_/CLK _211_/D max_cap79/X VGND VGND VPWR VPWR _211_/Q sky130_fd_sc_hd__dfrtp_2
X_142_ _225_/D _142_/B VGND VGND VPWR VPWR _201_/D sky130_fd_sc_hd__xor2_2
XFILLER_24_135 VGND VGND VPWR VPWR sky130_fd_sc_hd__decap_3
XFILLER_2_70 VGND VGND VPWR VPWR sky130_fd_sc_hd__fill_1
XFILLER_7_37 VGND VGND VPWR VPWR sky130_fd_sc_hd__fill_1
X_125_ _125_/A1 _120_/X _126_/B VGND VGND VPWR VPWR _194_/D sky130_fd_sc_hd__o21a_2
XFILLER_16_24 VGND VGND VPWR VPWR sky130_fd_sc_hd__decap_3
X_108_ _217_/Q _108_/B VGND VGND VPWR VPWR _108_/X sky130_fd_sc_hd__xor2_2
XFILLER_8_80 VGND VGND VPWR VPWR sky130_fd_sc_hd__decap_3
XFILLER_4_27 VGND VGND VPWR VPWR sky130_fd_sc_hd__fill_1
XFILLER_13_69 VGND VGND VPWR VPWR sky130_fd_sc_hd__decap_3
XFILLER_24_35 VGND VGND VPWR VPWR sky130_fd_sc_hd__fill_1
XFILLER_24_57 VGND VGND VPWR VPWR sky130_fd_sc_hd__decap_3
Xinput5 axi_araddr[13] VGND VGND VPWR VPWR _091_/B sky130_fd_sc_hd__clkdlybuf4s25_1
XFILLER_19_35 VGND VGND VPWR VPWR sky130_fd_sc_hd__decap_3
XFILLER_19_57 VGND VGND VPWR VPWR sky130_fd_sc_hd__fill_1
XFILLER_18_144 VGND VGND VPWR VPWR sky130_fd_sc_hd__decap_3
X_210_ _214_/CLK _210_/D max_cap79/X VGND VGND VPWR VPWR _210_/Q sky130_fd_sc_hd__dfrtp_2
X_141_ _199_/Q _200_/Q _201_/Q _141_/D VGND VGND VPWR VPWR _141_/X sky130_fd_sc_hd__and4_2
XFILLER_21_14 VGND VGND VPWR VPWR sky130_fd_sc_hd__decap_3
X_124_ _131_/B _131_/C VGND VGND VPWR VPWR _126_/B sky130_fd_sc_hd__nand2_2
XTAP_TAPCELL_ROW_11_80 VGND VPWR sky130_fd_sc_hd__tapvpwrvgnd_1
XFILLER_21_128 VGND VGND VPWR VPWR sky130_fd_sc_hd__decap_3
Xinput30 axi_araddr[7] VGND VGND VPWR VPWR _085_/B sky130_fd_sc_hd__clkdlybuf4s25_1
XTAP_TAPCELL_ROW_7_70 VGND VPWR sky130_fd_sc_hd__tapvpwrvgnd_1
XFILLER_16_69 VGND VGND VPWR VPWR sky130_fd_sc_hd__fill_2
X_107_ _216_/Q _107_/B VGND VGND VPWR VPWR _107_/X sky130_fd_sc_hd__xor2_2
XFILLER_5_60 VGND VGND VPWR VPWR sky130_fd_sc_hd__fill_1
XFILLER_14_91 VGND VGND VPWR VPWR sky130_fd_sc_hd__decap_3
XPHY_EDGE_ROW_23_Left_48 VGND VGND VPWR VPWR sky130_fd_sc_hd__decap_3
Xinput6 axi_araddr[14] VGND VGND VPWR VPWR _092_/B sky130_fd_sc_hd__clkdlybuf4s25_1
X_140_ _140_/A _142_/B VGND VGND VPWR VPWR _200_/D sky130_fd_sc_hd__nor2_2
XPHY_EDGE_ROW_23_Right_23 VGND VGND VPWR VPWR sky130_fd_sc_hd__decap_3
XPHY_EDGE_ROW_14_Right_14 VGND VGND VPWR VPWR sky130_fd_sc_hd__decap_3
Xmax_cap79 input33/X VGND VGND VPWR VPWR max_cap79/X sky130_fd_sc_hd__buf_12
XTAP_TAPCELL_ROW_11_81 VGND VPWR sky130_fd_sc_hd__tapvpwrvgnd_1
XFILLER_7_28 VGND VGND VPWR VPWR sky130_fd_sc_hd__decap_3
Xinput20 axi_araddr[27] VGND VGND VPWR VPWR _105_/B sky130_fd_sc_hd__clkdlybuf4s25_1
Xinput31 axi_araddr[8] VGND VGND VPWR VPWR _086_/B sky130_fd_sc_hd__clkdlybuf4s25_1
X_123_ _191_/Q _192_/Q _193_/Q _194_/Q VGND VGND VPWR VPWR _131_/C sky130_fd_sc_hd__and4_2
XTAP_TAPCELL_ROW_7_71 VGND VPWR sky130_fd_sc_hd__tapvpwrvgnd_1
XPHY_EDGE_ROW_10_Left_35 VGND VGND VPWR VPWR sky130_fd_sc_hd__decap_3
X_106_ _215_/Q _106_/B VGND VGND VPWR VPWR _106_/X sky130_fd_sc_hd__xor2_2
XPHY_EDGE_ROW_4_Right_4 VGND VGND VPWR VPWR sky130_fd_sc_hd__decap_3
XFILLER_4_18 VGND VGND VPWR VPWR sky130_fd_sc_hd__decap_3
XFILLER_4_29 VGND VGND VPWR VPWR sky130_fd_sc_hd__decap_3
XFILLER_14_81 VGND VGND VPWR VPWR sky130_fd_sc_hd__decap_3
Xinput7 axi_araddr[15] VGND VGND VPWR VPWR _093_/B sky130_fd_sc_hd__clkdlybuf4s25_1
XFILLER_19_26 VGND VGND VPWR VPWR sky130_fd_sc_hd__decap_3
XFILLER_4_3 VGND VGND VPWR VPWR sky130_fd_sc_hd__decap_3
X_199_ _226_/CLK _199_/D max_cap79/X VGND VGND VPWR VPWR _199_/Q sky130_fd_sc_hd__dfrtp_2
XFILLER_24_138 VGND VGND VPWR VPWR sky130_fd_sc_hd__fill_2
XFILLER_11_60 VGND VGND VPWR VPWR sky130_fd_sc_hd__decap_3
Xriscv_soc_top VGND VGND VPWR VPWR riscv_soc_top/HI axi_bresp[1] sky130_fd_sc_hd__conb_1
X_122_ _120_/X _122_/B VGND VGND VPWR VPWR _193_/D sky130_fd_sc_hd__and2b_2
XFILLER_16_27 VGND VGND VPWR VPWR sky130_fd_sc_hd__fill_1
XFILLER_20_141 VGND VGND VPWR VPWR sky130_fd_sc_hd__decap_3
XFILLER_21_119 VGND VGND VPWR VPWR sky130_fd_sc_hd__decap_3
Xinput10 axi_araddr[18] VGND VGND VPWR VPWR _096_/B sky130_fd_sc_hd__clkdlybuf4s25_1
Xinput21 axi_araddr[28] VGND VGND VPWR VPWR _106_/B sky130_fd_sc_hd__clkdlybuf4s25_1
Xinput32 axi_araddr[9] VGND VGND VPWR VPWR _087_/B sky130_fd_sc_hd__clkdlybuf4s25_1
X_105_ _214_/Q _105_/B VGND VGND VPWR VPWR _105_/X sky130_fd_sc_hd__xor2_2
XFILLER_22_81 VGND VGND VPWR VPWR sky130_fd_sc_hd__decap_3
XFILLER_8_83 VGND VGND VPWR VPWR sky130_fd_sc_hd__fill_1
XFILLER_17_70 VGND VGND VPWR VPWR sky130_fd_sc_hd__decap_3
XTAP_TAPCELL_ROW_4_62 VGND VPWR sky130_fd_sc_hd__tapvpwrvgnd_1
XFILLER_24_27 VGND VGND VPWR VPWR sky130_fd_sc_hd__fill_1
XFILLER_24_49 VGND VGND VPWR VPWR sky130_fd_sc_hd__fill_2
Xinput8 axi_araddr[16] VGND VGND VPWR VPWR _094_/B sky130_fd_sc_hd__clkdlybuf4s25_1
XFILLER_10_29 VGND VGND VPWR VPWR sky130_fd_sc_hd__decap_3
X_198_ _226_/CLK _198_/D max_cap79/X VGND VGND VPWR VPWR _198_/Q sky130_fd_sc_hd__dfrtp_2
XFILLER_21_17 VGND VGND VPWR VPWR sky130_fd_sc_hd__decap_3
XFILLER_24_106 VGND VGND VPWR VPWR sky130_fd_sc_hd__decap_3
XFILLER_11_50 VGND VGND VPWR VPWR sky130_fd_sc_hd__decap_3
X_121_ _191_/Q _192_/Q _131_/B _193_/Q VGND VGND VPWR VPWR _122_/B sky130_fd_sc_hd__a31o_2
Xinput11 axi_araddr[19] VGND VGND VPWR VPWR _097_/B sky130_fd_sc_hd__clkdlybuf4s25_1
Xinput22 axi_araddr[29] VGND VGND VPWR VPWR _107_/B sky130_fd_sc_hd__clkdlybuf4s25_1
Xinput33 rst_n VGND VGND VPWR VPWR input33/X sky130_fd_sc_hd__buf_4
XFILLER_20_120 VGND VGND VPWR VPWR sky130_fd_sc_hd__decap_3
X_104_ _213_/Q _104_/B VGND VGND VPWR VPWR _104_/X sky130_fd_sc_hd__xor2_2
XFILLER_17_60 VGND VGND VPWR VPWR sky130_fd_sc_hd__fill_2
XTAP_TAPCELL_ROW_4_63 VGND VPWR sky130_fd_sc_hd__tapvpwrvgnd_1
XFILLER_12_3 VGND VGND VPWR VPWR sky130_fd_sc_hd__decap_3
XFILLER_14_72 VGND VGND VPWR VPWR sky130_fd_sc_hd__decap_3
XFILLER_14_94 VGND VGND VPWR VPWR sky130_fd_sc_hd__fill_2
Xinput9 axi_araddr[17] VGND VGND VPWR VPWR _095_/B sky130_fd_sc_hd__clkdlybuf4s25_1
XFILLER_18_137 VGND VGND VPWR VPWR sky130_fd_sc_hd__decap_3
X_197_ _223_/CLK _197_/D max_cap79/X VGND VGND VPWR VPWR _197_/Q sky130_fd_sc_hd__dfrtp_2
XFILLER_24_129 VGND VGND VPWR VPWR sky130_fd_sc_hd__decap_3
XPHY_EDGE_ROW_10_Right_10 VGND VGND VPWR VPWR sky130_fd_sc_hd__decap_3
X_120_ _191_/Q _192_/Q _193_/Q _131_/B VGND VGND VPWR VPWR _120_/X sky130_fd_sc_hd__and4_2
Xinput12 axi_araddr[1] VGND VGND VPWR VPWR _079_/B sky130_fd_sc_hd__clkdlybuf4s25_1
Xinput23 axi_araddr[2] VGND VGND VPWR VPWR _080_/B sky130_fd_sc_hd__clkdlybuf4s25_1
Xinput34 uart_rx VGND VGND VPWR VPWR _185_/B sky130_fd_sc_hd__clkdlybuf4s25_1
X_103_ _212_/Q _103_/B VGND VGND VPWR VPWR _103_/X sky130_fd_sc_hd__xor2_2
XPHY_EDGE_ROW_14_Left_39 VGND VGND VPWR VPWR sky130_fd_sc_hd__decap_3
XTAP_TAPCELL_ROW_4_64 VGND VPWR sky130_fd_sc_hd__tapvpwrvgnd_1
XPHY_EDGE_ROW_8_Right_8 VGND VGND VPWR VPWR sky130_fd_sc_hd__decap_3
XFILLER_5_31 VGND VGND VPWR VPWR sky130_fd_sc_hd__fill_1
XFILLER_24_29 VGND VGND VPWR VPWR sky130_fd_sc_hd__decap_3
XPHY_EDGE_ROW_17_Left_42 VGND VGND VPWR VPWR sky130_fd_sc_hd__decap_3
XFILLER_19_29 VGND VGND VPWR VPWR sky130_fd_sc_hd__decap_3
XFILLER_4_6 VGND VGND VPWR VPWR sky130_fd_sc_hd__decap_3
XPHY_EDGE_ROW_2_Left_27 VGND VGND VPWR VPWR sky130_fd_sc_hd__decap_3
X_196_ _223_/CLK _196_/D max_cap79/X VGND VGND VPWR VPWR _196_/Q sky130_fd_sc_hd__dfrtp_2
XTAP_TAPCELL_ROW_19_100 VGND VPWR sky130_fd_sc_hd__tapvpwrvgnd_1
XFILLER_23_130 VGND VGND VPWR VPWR sky130_fd_sc_hd__decap_3
XFILLER_11_63 VGND VGND VPWR VPWR sky130_fd_sc_hd__decap_3
XFILLER_14_141 VGND VGND VPWR VPWR sky130_fd_sc_hd__decap_3
Xinput13 axi_araddr[20] VGND VGND VPWR VPWR _098_/B sky130_fd_sc_hd__clkdlybuf4s25_1
Xinput24 axi_araddr[30] VGND VGND VPWR VPWR _108_/B sky130_fd_sc_hd__clkdlybuf4s25_1
X_179_ _215_/Q _216_/Q VGND VGND VPWR VPWR _182_/D sky130_fd_sc_hd__and2_2
XFILLER_20_111 VGND VGND VPWR VPWR sky130_fd_sc_hd__decap_3
XFILLER_20_144 VGND VGND VPWR VPWR sky130_fd_sc_hd__decap_3
XFILLER_11_144 VGND VGND VPWR VPWR sky130_fd_sc_hd__decap_3
Xclkbuf_2_2__f_clk clkbuf_0_clk/X VGND VGND VPWR VPWR _226_/CLK sky130_fd_sc_hd__clkbuf_16
X_102_ _211_/Q _102_/B VGND VGND VPWR VPWR _102_/X sky130_fd_sc_hd__xor2_2
XPHY_EDGE_ROW_5_Left_30 VGND VGND VPWR VPWR sky130_fd_sc_hd__decap_3
XFILLER_17_73 VGND VGND VPWR VPWR sky130_fd_sc_hd__fill_2
XFILLER_4_118 VGND VGND VPWR VPWR sky130_fd_sc_hd__fill_1
XTAP_TAPCELL_ROW_17_95 VGND VPWR sky130_fd_sc_hd__tapvpwrvgnd_1
XFILLER_0_110 VGND VGND VPWR VPWR sky130_fd_sc_hd__fill_2
XFILLER_14_85 VGND VGND VPWR VPWR sky130_fd_sc_hd__decap_3
XTAP_TAPCELL_ROW_1_55 VGND VPWR sky130_fd_sc_hd__tapvpwrvgnd_1
XFILLER_19_19 VGND VGND VPWR VPWR sky130_fd_sc_hd__fill_1
XFILLER_18_106 VGND VGND VPWR VPWR sky130_fd_sc_hd__decap_3
XFILLER_24_109 VGND VGND VPWR VPWR sky130_fd_sc_hd__decap_3
X_195_ _220_/CLK _195_/D max_cap79/X VGND VGND VPWR VPWR _195_/Q sky130_fd_sc_hd__dfrtp_2
XTAP_TAPCELL_ROW_19_101 VGND VPWR sky130_fd_sc_hd__tapvpwrvgnd_1
XFILLER_11_53 VGND VGND VPWR VPWR sky130_fd_sc_hd__decap_3
Xinput14 axi_araddr[21] VGND VGND VPWR VPWR _099_/B sky130_fd_sc_hd__clkdlybuf4s25_1
Xinput25 axi_araddr[31] VGND VGND VPWR VPWR _109_/B sky130_fd_sc_hd__clkdlybuf4s25_1
XFILLER_20_123 VGND VGND VPWR VPWR sky130_fd_sc_hd__fill_1
X_178_ _178_/A _178_/B VGND VGND VPWR VPWR _215_/D sky130_fd_sc_hd__nor2_2
XTAP_TAPCELL_ROW_22_107 VGND VPWR sky130_fd_sc_hd__tapvpwrvgnd_1
X_101_ _210_/Q _101_/B VGND VGND VPWR VPWR _101_/X sky130_fd_sc_hd__xor2_2
XTAP_TAPCELL_ROW_17_96 VGND VPWR sky130_fd_sc_hd__tapvpwrvgnd_1
XFILLER_12_6 VGND VGND VPWR VPWR sky130_fd_sc_hd__fill_1
XFILLER_17_41 VGND VGND VPWR VPWR sky130_fd_sc_hd__decap_3
XFILLER_10_3 VGND VGND VPWR VPWR sky130_fd_sc_hd__fill_1
XFILLER_5_11 VGND VGND VPWR VPWR sky130_fd_sc_hd__decap_3
XFILLER_5_77 VGND VGND VPWR VPWR sky130_fd_sc_hd__decap_3
XFILLER_14_75 VGND VGND VPWR VPWR sky130_fd_sc_hd__decap_3
XTAP_TAPCELL_ROW_1_56 VGND VPWR sky130_fd_sc_hd__tapvpwrvgnd_1
XFILLER_2_12 VGND VGND VPWR VPWR sky130_fd_sc_hd__decap_3
X_194_ _223_/CLK _194_/D input33/X VGND VGND VPWR VPWR _194_/Q sky130_fd_sc_hd__dfrtp_2
XFILLER_23_121 VGND VGND VPWR VPWR sky130_fd_sc_hd__decap_3
Xinput15 axi_araddr[22] VGND VGND VPWR VPWR _100_/B sky130_fd_sc_hd__clkdlybuf4s25_1
Xinput26 axi_araddr[3] VGND VGND VPWR VPWR _081_/B sky130_fd_sc_hd__clkdlybuf4s25_1
X_177_ _215_/Q _180_/A _182_/C VGND VGND VPWR VPWR _178_/B sky130_fd_sc_hd__and3_2
XTAP_TAPCELL_ROW_22_108 VGND VPWR sky130_fd_sc_hd__tapvpwrvgnd_1
XFILLER_11_113 VGND VGND VPWR VPWR sky130_fd_sc_hd__fill_2
XFILLER_22_53 VGND VGND VPWR VPWR sky130_fd_sc_hd__fill_2
X_100_ _209_/Q _100_/B VGND VGND VPWR VPWR _100_/X sky130_fd_sc_hd__xor2_2
XPHY_EDGE_ROW_17_Right_17 VGND VGND VPWR VPWR sky130_fd_sc_hd__decap_3
XTAP_TAPCELL_ROW_14_87 VGND VPWR sky130_fd_sc_hd__tapvpwrvgnd_1
XFILLER_4_9 VGND VGND VPWR VPWR sky130_fd_sc_hd__decap_3
X_193_ _223_/CLK _193_/D input33/X VGND VGND VPWR VPWR _193_/Q sky130_fd_sc_hd__dfrtp_2
XFILLER_11_44 VGND VGND VPWR VPWR sky130_fd_sc_hd__decap_3
XFILLER_11_66 VGND VGND VPWR VPWR sky130_fd_sc_hd__fill_1
XFILLER_23_111 VGND VGND VPWR VPWR sky130_fd_sc_hd__fill_1
XFILLER_23_133 VGND VGND VPWR VPWR sky130_fd_sc_hd__decap_3
XFILLER_2_6 VGND VGND VPWR VPWR sky130_fd_sc_hd__decap_3
XFILLER_14_144 VGND VGND VPWR VPWR sky130_fd_sc_hd__decap_3
Xinput16 axi_araddr[23] VGND VGND VPWR VPWR _101_/B sky130_fd_sc_hd__clkdlybuf4s25_1
Xinput27 axi_araddr[4] VGND VGND VPWR VPWR _082_/B sky130_fd_sc_hd__clkdlybuf4s25_1
X_176_ _182_/B _182_/C _215_/Q VGND VGND VPWR VPWR _178_/A sky130_fd_sc_hd__a21oi_2
XFILLER_20_114 VGND VGND VPWR VPWR sky130_fd_sc_hd__decap_3
XTAP_TAPCELL_ROW_22_109 VGND VPWR sky130_fd_sc_hd__tapvpwrvgnd_1
XFILLER_0_3 VGND VGND VPWR VPWR sky130_fd_sc_hd__fill_1
X_159_ _160_/B _165_/D _209_/Q VGND VGND VPWR VPWR _161_/A sky130_fd_sc_hd__a21oi_2
XPHY_EDGE_ROW_9_Left_34 VGND VGND VPWR VPWR sky130_fd_sc_hd__decap_3
XFILLER_0_146 VGND VGND VPWR VPWR sky130_fd_sc_hd__fill_1
XFILLER_5_57 VGND VGND VPWR VPWR sky130_fd_sc_hd__decap_3
XTAP_TAPCELL_ROW_14_88 VGND VPWR sky130_fd_sc_hd__tapvpwrvgnd_1
XFILLER_14_44 VGND VGND VPWR VPWR sky130_fd_sc_hd__fill_2
XFILLER_14_88 VGND VGND VPWR VPWR sky130_fd_sc_hd__decap_3
XFILLER_18_109 VGND VGND VPWR VPWR sky130_fd_sc_hd__fill_2
X_192_ _223_/CLK _192_/D input33/X VGND VGND VPWR VPWR _192_/Q sky130_fd_sc_hd__dfrtp_2
XPHY_EDGE_ROW_22_Left_47 VGND VGND VPWR VPWR sky130_fd_sc_hd__decap_3
XFILLER_11_78 VGND VGND VPWR VPWR sky130_fd_sc_hd__decap_3
Xinput17 axi_araddr[24] VGND VGND VPWR VPWR _102_/B sky130_fd_sc_hd__clkdlybuf4s25_1
Xinput28 axi_araddr[5] VGND VGND VPWR VPWR _083_/B sky130_fd_sc_hd__clkdlybuf4s25_1
X_175_ _182_/B _182_/C _172_/X _214_/Q VGND VGND VPWR VPWR _214_/D sky130_fd_sc_hd__o2bb2a_2
X_158_ _160_/B _165_/D _156_/Y VGND VGND VPWR VPWR _208_/D sky130_fd_sc_hd__a21oi_2
X_089_ _198_/Q _089_/B VGND VGND VPWR VPWR _089_/X sky130_fd_sc_hd__xor2_2
XFILLER_17_44 VGND VGND VPWR VPWR sky130_fd_sc_hd__decap_3
XPHY_EDGE_ROW_3_Right_3 VGND VGND VPWR VPWR sky130_fd_sc_hd__decap_3
XFILLER_5_14 VGND VGND VPWR VPWR sky130_fd_sc_hd__decap_3
XTAP_TAPCELL_ROW_14_89 VGND VPWR sky130_fd_sc_hd__tapvpwrvgnd_1
XFILLER_14_34 VGND VGND VPWR VPWR sky130_fd_sc_hd__fill_2
XFILLER_14_78 VGND VGND VPWR VPWR sky130_fd_sc_hd__decap_3
XFILLER_2_15 VGND VGND VPWR VPWR sky130_fd_sc_hd__decap_3
X_191_ _223_/CLK _191_/D input33/X VGND VGND VPWR VPWR _191_/Q sky130_fd_sc_hd__dfrtp_2
XFILLER_11_57 VGND VGND VPWR VPWR sky130_fd_sc_hd__decap_3
XFILLER_23_124 VGND VGND VPWR VPWR sky130_fd_sc_hd__decap_3
XFILLER_14_102 VGND VGND VPWR VPWR sky130_fd_sc_hd__fill_2
Xinput18 axi_araddr[25] VGND VGND VPWR VPWR _103_/B sky130_fd_sc_hd__clkdlybuf4s25_1
Xinput29 axi_araddr[6] VGND VGND VPWR VPWR _084_/B sky130_fd_sc_hd__clkdlybuf4s25_1
X_174_ _211_/Q _212_/Q _213_/Q _214_/Q VGND VGND VPWR VPWR _182_/C sky130_fd_sc_hd__and4_2
X_226_ _226_/CLK _226_/D max_cap79/X VGND VGND VPWR VPWR _226_/Q sky130_fd_sc_hd__dfrtp_2
X_157_ _207_/Q _208_/Q VGND VGND VPWR VPWR _165_/D sky130_fd_sc_hd__and2_2
X_088_ _197_/Q _088_/B VGND VGND VPWR VPWR _088_/X sky130_fd_sc_hd__xor2_2
X_209_ _214_/CLK _209_/D max_cap79/X VGND VGND VPWR VPWR _209_/Q sky130_fd_sc_hd__dfrtp_2
XPHY_EDGE_ROW_22_Right_22 VGND VGND VPWR VPWR sky130_fd_sc_hd__decap_3
XPHY_EDGE_ROW_13_Right_13 VGND VGND VPWR VPWR sky130_fd_sc_hd__decap_3
XFILLER_14_24 VGND VGND VPWR VPWR sky130_fd_sc_hd__decap_3
XFILLER_17_144 VGND VGND VPWR VPWR sky130_fd_sc_hd__decap_3
X_190_ _220_/CLK _190_/D input33/X VGND VGND VPWR VPWR _190_/Q sky130_fd_sc_hd__dfrtp_2
XFILLER_23_136 VGND VGND VPWR VPWR sky130_fd_sc_hd__decap_3
XFILLER_11_25 VGND VGND VPWR VPWR sky130_fd_sc_hd__decap_3
XFILLER_11_47 VGND VGND VPWR VPWR sky130_fd_sc_hd__decap_3
XFILLER_14_125 VGND VGND VPWR VPWR sky130_fd_sc_hd__fill_2
XFILLER_2_9 VGND VGND VPWR VPWR sky130_fd_sc_hd__decap_3
Xinput19 axi_araddr[26] VGND VGND VPWR VPWR _104_/B sky130_fd_sc_hd__clkdlybuf4s25_1
X_173_ _213_/Q _171_/B _172_/X VGND VGND VPWR VPWR _213_/D sky130_fd_sc_hd__o21ba_2
XFILLER_20_117 VGND VGND VPWR VPWR sky130_fd_sc_hd__decap_3
XFILLER_8_37 VGND VGND VPWR VPWR sky130_fd_sc_hd__fill_2
X_225_ _226_/CLK _225_/D max_cap79/X VGND VGND VPWR VPWR _225_/Q sky130_fd_sc_hd__dfrtp_2
X_156_ _207_/Q _160_/B hold97/X VGND VGND VPWR VPWR _156_/Y sky130_fd_sc_hd__a21oi_2
X_087_ _196_/Q _087_/B VGND VGND VPWR VPWR _087_/X sky130_fd_sc_hd__xor2_2
XFILLER_17_57 VGND VGND VPWR VPWR sky130_fd_sc_hd__decap_3
XFILLER_0_71 VGND VGND VPWR VPWR sky130_fd_sc_hd__decap_3
X_208_ _214_/CLK _208_/D max_cap79/X VGND VGND VPWR VPWR _208_/Q sky130_fd_sc_hd__dfrtp_2
X_139_ _199_/Q _200_/Q _141_/D VGND VGND VPWR VPWR _142_/B sky130_fd_sc_hd__and3_2
Xclkbuf_2_3__f_clk clkbuf_0_clk/X VGND VGND VPWR VPWR _214_/CLK sky130_fd_sc_hd__clkbuf_16
XTAP_TAPCELL_ROW_15_90 VGND VPWR sky130_fd_sc_hd__tapvpwrvgnd_1
X_172_ _211_/Q _212_/Q _213_/Q _180_/A VGND VGND VPWR VPWR _172_/X sky130_fd_sc_hd__and4_2
X_224_ _226_/CLK _224_/D max_cap79/X VGND VGND VPWR VPWR _224_/Q sky130_fd_sc_hd__dfrtp_2
X_155_ _155_/A _160_/B VGND VGND VPWR VPWR _207_/D sky130_fd_sc_hd__xor2_2
X_086_ _195_/Q _086_/B VGND VGND VPWR VPWR _086_/X sky130_fd_sc_hd__xor2_2
XFILLER_17_47 VGND VGND VPWR VPWR sky130_fd_sc_hd__decap_3
XFILLER_24_3 VGND VGND VPWR VPWR sky130_fd_sc_hd__decap_3
X_207_ _214_/CLK _207_/D max_cap79/X VGND VGND VPWR VPWR _207_/Q sky130_fd_sc_hd__dfrtp_2
X_138_ _199_/Q _141_/D _200_/Q VGND VGND VPWR VPWR _140_/A sky130_fd_sc_hd__a21oi_2
XPHY_EDGE_ROW_13_Left_38 VGND VGND VPWR VPWR sky130_fd_sc_hd__decap_3
XFILLER_5_17 VGND VGND VPWR VPWR sky130_fd_sc_hd__decap_3
XFILLER_5_28 VGND VGND VPWR VPWR sky130_fd_sc_hd__decap_3
XPHY_EDGE_ROW_7_Right_7 VGND VGND VPWR VPWR sky130_fd_sc_hd__decap_3
XTAP_TAPCELL_ROW_15_91 VGND VPWR sky130_fd_sc_hd__tapvpwrvgnd_1
XPHY_EDGE_ROW_16_Left_41 VGND VGND VPWR VPWR sky130_fd_sc_hd__decap_3
XFILLER_15_91 VGND VGND VPWR VPWR sky130_fd_sc_hd__decap_3
XFILLER_2_18 VGND VGND VPWR VPWR sky130_fd_sc_hd__fill_2
XFILLER_2_29 VGND VGND VPWR VPWR sky130_fd_sc_hd__fill_2
XFILLER_23_127 VGND VGND VPWR VPWR sky130_fd_sc_hd__decap_3
XPHY_EDGE_ROW_1_Left_26 VGND VGND VPWR VPWR sky130_fd_sc_hd__decap_3
X_171_ _171_/A _171_/B VGND VGND VPWR VPWR _212_/D sky130_fd_sc_hd__nor2_2
XFILLER_22_15 VGND VGND VPWR VPWR sky130_fd_sc_hd__decap_3
X_223_ _223_/CLK _223_/D max_cap79/X VGND VGND VPWR VPWR _223_/Q sky130_fd_sc_hd__dfrtp_2
X_154_ _154_/A1 _151_/B _160_/B VGND VGND VPWR VPWR _206_/D sky130_fd_sc_hd__o21ba_2
X_085_ _194_/Q _085_/B VGND VGND VPWR VPWR _085_/X sky130_fd_sc_hd__xor2_2
X_206_ _226_/CLK _206_/D max_cap79/X VGND VGND VPWR VPWR _206_/Q sky130_fd_sc_hd__dfrtp_2
X_137_ _199_/Q _141_/D VGND VGND VPWR VPWR _199_/D sky130_fd_sc_hd__xor2_2
XFILLER_0_95 VGND VGND VPWR VPWR sky130_fd_sc_hd__fill_2
XFILLER_14_27 VGND VGND VPWR VPWR sky130_fd_sc_hd__fill_1
Xhold90 _201_/Q VGND VGND VPWR VPWR _225_/D sky130_fd_sc_hd__dlygate4sd3_1
XFILLER_17_103 VGND VGND VPWR VPWR sky130_fd_sc_hd__fill_2
X_170_ _211_/Q _212_/Q _182_/B VGND VGND VPWR VPWR _171_/B sky130_fd_sc_hd__and3_2
XTAP_TAPCELL_ROW_24_112 VGND VPWR sky130_fd_sc_hd__tapvpwrvgnd_1
XFILLER_9_121 VGND VGND VPWR VPWR sky130_fd_sc_hd__decap_3
XTAP_TAPCELL_ROW_12_82 VGND VPWR sky130_fd_sc_hd__tapvpwrvgnd_1
X_222_ _226_/CLK _222_/D max_cap79/X VGND VGND VPWR VPWR _222_/Q sky130_fd_sc_hd__dfrtp_2
X_153_ _198_/Q _166_/B _166_/C _165_/C VGND VGND VPWR VPWR _160_/B sky130_fd_sc_hd__and4_2
X_084_ _193_/Q _084_/B VGND VGND VPWR VPWR _084_/X sky130_fd_sc_hd__xor2_2
XTAP_TAPCELL_ROW_8_72 VGND VPWR sky130_fd_sc_hd__tapvpwrvgnd_1
X_205_ _226_/CLK _205_/D max_cap79/X VGND VGND VPWR VPWR _205_/Q sky130_fd_sc_hd__dfrtp_2
X_136_ _141_/D _136_/B VGND VGND VPWR VPWR _198_/D sky130_fd_sc_hd__nor2_2
XFILLER_0_74 VGND VGND VPWR VPWR sky130_fd_sc_hd__fill_2
XFILLER_0_85 VGND VGND VPWR VPWR sky130_fd_sc_hd__fill_2
XFILLER_9_72 VGND VGND VPWR VPWR sky130_fd_sc_hd__decap_3
X_119_ _119_/A _119_/B VGND VGND VPWR VPWR _192_/D sky130_fd_sc_hd__xnor2_2
XFILLER_20_93 VGND VGND VPWR VPWR sky130_fd_sc_hd__decap_3
Xhold91 _186_/Q VGND VGND VPWR VPWR _185_/A sky130_fd_sc_hd__dlygate4sd3_1
XFILLER_17_126 VGND VGND VPWR VPWR sky130_fd_sc_hd__decap_3
Xoutput70 _219_/Q VGND VGND VPWR VPWR gpio_out[0] sky130_fd_sc_hd__clkdlybuf4s25_1
XFILLER_7_3 VGND VGND VPWR VPWR sky130_fd_sc_hd__decap_3
XTAP_TAPCELL_ROW_24_113 VGND VPWR sky130_fd_sc_hd__tapvpwrvgnd_1
XTAP_TAPCELL_ROW_21_105 VGND VPWR sky130_fd_sc_hd__tapvpwrvgnd_1
XTAP_TAPCELL_ROW_12_83 VGND VPWR sky130_fd_sc_hd__tapvpwrvgnd_1
XFILLER_12_50 VGND VGND VPWR VPWR sky130_fd_sc_hd__decap_3
X_221_ _223_/CLK _221_/D max_cap79/X VGND VGND VPWR VPWR _221_/Q sky130_fd_sc_hd__dfrtp_2
X_152_ _203_/Q _204_/Q _205_/Q _206_/Q VGND VGND VPWR VPWR _165_/C sky130_fd_sc_hd__and4_2
X_083_ _192_/Q _083_/B VGND VGND VPWR VPWR _083_/X sky130_fd_sc_hd__xor2_2
XTAP_TAPCELL_ROW_8_73 VGND VPWR sky130_fd_sc_hd__tapvpwrvgnd_1
X_204_ _226_/CLK _204_/D max_cap79/X VGND VGND VPWR VPWR _204_/Q sky130_fd_sc_hd__dfrtp_2
XFILLER_24_6 VGND VGND VPWR VPWR sky130_fd_sc_hd__decap_3
X_135_ _198_/Q _166_/B VGND VGND VPWR VPWR _136_/B sky130_fd_sc_hd__nor2_2
X_118_ _191_/Q _131_/B VGND VGND VPWR VPWR _191_/D sky130_fd_sc_hd__xor2_2
XFILLER_20_83 VGND VGND VPWR VPWR sky130_fd_sc_hd__fill_1
Xhold92 _187_/Q VGND VGND VPWR VPWR _077_/A sky130_fd_sc_hd__dlygate4sd3_1
XFILLER_6_85 VGND VGND VPWR VPWR sky130_fd_sc_hd__decap_3
XFILLER_15_94 VGND VGND VPWR VPWR sky130_fd_sc_hd__decap_3
Xoutput60 _108_/X VGND VGND VPWR VPWR axi_rdata[30] sky130_fd_sc_hd__clkdlybuf4s25_1
Xoutput71 _220_/Q VGND VGND VPWR VPWR gpio_out[1] sky130_fd_sc_hd__clkdlybuf4s25_1
XFILLER_22_141 VGND VGND VPWR VPWR sky130_fd_sc_hd__decap_3
XTAP_TAPCELL_ROW_24_114 VGND VPWR sky130_fd_sc_hd__tapvpwrvgnd_1
XFILLER_9_145 VGND VGND VPWR VPWR sky130_fd_sc_hd__fill_2
XFILLER_22_18 VGND VGND VPWR VPWR sky130_fd_sc_hd__fill_2
XFILLER_22_29 VGND VGND VPWR VPWR sky130_fd_sc_hd__decap_3
XTAP_TAPCELL_ROW_21_106 VGND VPWR sky130_fd_sc_hd__tapvpwrvgnd_1
XFILLER_12_62 VGND VGND VPWR VPWR sky130_fd_sc_hd__fill_2
X_220_ _220_/CLK _220_/D max_cap79/X VGND VGND VPWR VPWR _220_/Q sky130_fd_sc_hd__dfrtp_2
X_151_ _151_/A _151_/B VGND VGND VPWR VPWR _205_/D sky130_fd_sc_hd__nor2_2
X_082_ _191_/Q _082_/B VGND VGND VPWR VPWR _082_/X sky130_fd_sc_hd__xor2_2
XTAP_TAPCELL_ROW_12_84 VGND VPWR sky130_fd_sc_hd__tapvpwrvgnd_1
XTAP_TAPCELL_ROW_8_74 VGND VPWR sky130_fd_sc_hd__tapvpwrvgnd_1
XFILLER_3_129 VGND VGND VPWR VPWR sky130_fd_sc_hd__fill_2
XFILLER_17_6 VGND VGND VPWR VPWR sky130_fd_sc_hd__fill_1
X_203_ _226_/CLK _203_/D max_cap79/X VGND VGND VPWR VPWR _203_/Q sky130_fd_sc_hd__dfrtp_2
X_134_ _198_/Q _166_/B VGND VGND VPWR VPWR _141_/D sky130_fd_sc_hd__and2_2
XFILLER_9_41 VGND VGND VPWR VPWR sky130_fd_sc_hd__fill_2
XFILLER_18_50 VGND VGND VPWR VPWR sky130_fd_sc_hd__fill_1
X_117_ _191_/Q _131_/B VGND VGND VPWR VPWR _119_/B sky130_fd_sc_hd__nand2_2
XPHY_EDGE_ROW_8_Left_33 VGND VGND VPWR VPWR sky130_fd_sc_hd__decap_3
Xhold93 _195_/Q VGND VGND VPWR VPWR _219_/D sky130_fd_sc_hd__dlygate4sd3_1
Xoutput50 _099_/X VGND VGND VPWR VPWR axi_rdata[21] sky130_fd_sc_hd__clkdlybuf4s25_1
Xoutput61 _109_/X VGND VGND VPWR VPWR axi_rdata[31] sky130_fd_sc_hd__clkdlybuf4s25_1
Xoutput72 _221_/Q VGND VGND VPWR VPWR gpio_out[2] sky130_fd_sc_hd__clkdlybuf4s25_1
XFILLER_22_120 VGND VGND VPWR VPWR sky130_fd_sc_hd__decap_3
XTAP_TAPCELL_ROW_24_115 VGND VPWR sky130_fd_sc_hd__tapvpwrvgnd_1
XPHY_EDGE_ROW_21_Left_46 VGND VGND VPWR VPWR sky130_fd_sc_hd__decap_3
XFILLER_3_21 VGND VGND VPWR VPWR sky130_fd_sc_hd__fill_1
XFILLER_12_85 VGND VGND VPWR VPWR sky130_fd_sc_hd__decap_3
XFILLER_6_116 VGND VGND VPWR VPWR sky130_fd_sc_hd__decap_3
X_150_ _203_/Q _204_/Q _205_/Q _150_/D VGND VGND VPWR VPWR _151_/B sky130_fd_sc_hd__and4_2
X_081_ _190_/Q _081_/B VGND VGND VPWR VPWR _081_/X sky130_fd_sc_hd__xor2_2
XPHY_EDGE_ROW_16_Right_16 VGND VGND VPWR VPWR sky130_fd_sc_hd__decap_3
XFILLER_2_141 VGND VGND VPWR VPWR sky130_fd_sc_hd__decap_3
X_202_ _226_/CLK _202_/D max_cap79/X VGND VGND VPWR VPWR _202_/Q sky130_fd_sc_hd__dfrtp_2
X_133_ _166_/B _133_/B VGND VGND VPWR VPWR _197_/D sky130_fd_sc_hd__nor2_2
X_116_ _131_/B _116_/B VGND VGND VPWR VPWR _190_/D sky130_fd_sc_hd__and2b_2
XTAP_TAPCELL_ROW_5_65 VGND VPWR sky130_fd_sc_hd__tapvpwrvgnd_1
XPHY_EDGE_ROW_2_Right_2 VGND VGND VPWR VPWR sky130_fd_sc_hd__decap_3
XFILLER_20_85 VGND VGND VPWR VPWR sky130_fd_sc_hd__fill_1
XFILLER_20_96 VGND VGND VPWR VPWR sky130_fd_sc_hd__fill_2
Xhold94 _199_/Q VGND VGND VPWR VPWR _223_/D sky130_fd_sc_hd__dlygate4sd3_1
XFILLER_15_63 VGND VGND VPWR VPWR sky130_fd_sc_hd__fill_2
XFILLER_17_129 VGND VGND VPWR VPWR sky130_fd_sc_hd__fill_2
Xoutput40 _090_/X VGND VGND VPWR VPWR axi_rdata[12] sky130_fd_sc_hd__clkdlybuf4s25_1
Xoutput51 _100_/X VGND VGND VPWR VPWR axi_rdata[22] sky130_fd_sc_hd__clkdlybuf4s25_1
Xoutput62 _081_/X VGND VGND VPWR VPWR axi_rdata[3] sky130_fd_sc_hd__clkdlybuf4s25_1
Xoutput73 _222_/Q VGND VGND VPWR VPWR gpio_out[3] sky130_fd_sc_hd__clkdlybuf4s25_1
XFILLER_22_132 VGND VGND VPWR VPWR sky130_fd_sc_hd__decap_3
XFILLER_7_6 VGND VGND VPWR VPWR sky130_fd_sc_hd__fill_1
XTAP_TAPCELL_ROW_24_116 VGND VPWR sky130_fd_sc_hd__tapvpwrvgnd_1
X_080_ _189_/Q _080_/B VGND VGND VPWR VPWR _080_/X sky130_fd_sc_hd__xor2_2
XFILLER_12_53 VGND VGND VPWR VPWR sky130_fd_sc_hd__decap_3
X_201_ _226_/CLK _201_/D max_cap79/X VGND VGND VPWR VPWR _201_/Q sky130_fd_sc_hd__dfrtp_2
X_132_ _126_/B _128_/Y _197_/Q VGND VGND VPWR VPWR _133_/B sky130_fd_sc_hd__o21ba_2
XFILLER_0_45 VGND VGND VPWR VPWR sky130_fd_sc_hd__decap_3
XFILLER_24_9 VGND VGND VPWR VPWR sky130_fd_sc_hd__fill_2
XFILLER_18_41 VGND VGND VPWR VPWR sky130_fd_sc_hd__decap_3
XFILLER_22_6 VGND VGND VPWR VPWR sky130_fd_sc_hd__decap_3
X_115_ _187_/Q _188_/Q _189_/Q _190_/Q VGND VGND VPWR VPWR _116_/B sky130_fd_sc_hd__a31o_2
XTAP_TAPCELL_ROW_5_66 VGND VPWR sky130_fd_sc_hd__tapvpwrvgnd_1
XFILLER_20_20 VGND VGND VPWR VPWR sky130_fd_sc_hd__decap_3
Xhold95 _218_/Q VGND VGND VPWR VPWR _184_/A sky130_fd_sc_hd__dlygate4sd3_1
XFILLER_15_53 VGND VGND VPWR VPWR sky130_fd_sc_hd__decap_3
Xoutput41 _091_/X VGND VGND VPWR VPWR axi_rdata[13] sky130_fd_sc_hd__clkdlybuf4s25_1
Xoutput52 _101_/X VGND VGND VPWR VPWR axi_rdata[23] sky130_fd_sc_hd__clkdlybuf4s25_1
XFILLER_16_141 VGND VGND VPWR VPWR sky130_fd_sc_hd__decap_3
Xoutput63 _082_/X VGND VGND VPWR VPWR axi_rdata[4] sky130_fd_sc_hd__clkdlybuf4s25_1
Xoutput74 _223_/Q VGND VGND VPWR VPWR gpio_out[4] sky130_fd_sc_hd__clkdlybuf4s25_1
.ends
